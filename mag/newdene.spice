* SPICE3 file created from newdene.ext - technology: sky130A

X0 gnd csvc_0/a_5628_n60# m2_4740_n7410# gnd sky130_fd_pr__nfet_01v8 ad=0.6 pd=3.2 as=0.6 ps=3.2 w=1 l=13.5
X1 gnd csvc_0/a_6958_1500# m2_4740_n7410# gnd sky130_fd_pr__nfet_01v8 ad=0.6 pd=3.2 as=0.6 ps=3.2 w=1 l=3.5
X2 gnd csvc_0/a_7398_1800# m2_4740_n7410# gnd sky130_fd_pr__nfet_01v8 ad=0.6 pd=3.2 as=0.6 ps=3.2 w=1 l=2
X3 gnd csvc_0/a_6558_900# m2_4740_n7410# gnd sky130_fd_pr__nfet_01v8 ad=0.6 pd=3.2 as=0.6 ps=3.2 w=1 l=6.5
X4 m2_4740_n7410# m2_4740_n7410# csvc_0/a_6788_n630# AND_0/Vdd sky130_fd_pr__pfet_01v8 ad=3 pd=11.2 as=3 ps=11.2 w=5 l=3
X5 csvc_0/a_6788_n630# a_1030_n8160# AND_0/Vdd AND_0/Vdd sky130_fd_pr__pfet_01v8 ad=3 pd=11.2 as=3 ps=11.2 w=5 l=0.2
X6 gnd csvc_0/a_6158_200# m2_4740_n7410# gnd sky130_fd_pr__nfet_01v8 ad=0.6 pd=3.2 as=0.6 ps=3.2 w=1 l=10
X7 AND_0/a_n2700_2180# AND_0/a AND_0/Vdd AND_0/Vdd sky130_fd_pr__pfet_01v8 ad=0.3 pd=1.6 as=0.6 ps=3.2 w=1 l=0.2
X8 AND_0/a_n2700_1720# AND_0/a gnd gnd sky130_fd_pr__nfet_01v8 ad=0.15 pd=1.1 as=0.3 ps=2.2 w=0.5 l=0.2
X9 AND_0/Vdd AND_0/b AND_0/a_n2700_2180# AND_0/Vdd sky130_fd_pr__pfet_01v8 ad=0.3 pd=1.6 as=0.3 ps=1.6 w=1 l=0.2
X10 AND_0/out AND_0/a_n2700_2180# AND_0/Vdd AND_0/Vdd sky130_fd_pr__pfet_01v8 ad=0.6 pd=3.2 as=0.3 ps=1.6 w=1 l=0.2
X11 AND_0/out AND_0/a_n2700_2180# gnd gnd sky130_fd_pr__nfet_01v8 ad=0.3 pd=2.2 as=0.3 ps=2.2 w=0.5 l=0.2
X12 AND_0/a_n2700_2180# AND_0/b AND_0/a_n2700_1720# gnd sky130_fd_pr__nfet_01v8 ad=0.3 pd=2.2 as=0.15 ps=1.1 w=0.5 l=0.2
X13 m2_3470_n16750# sw3cs_0/a_n260_n6040# sw3cs_0/a_n540_n5100# m2_3470_n16750# sky130_fd_pr__pfet_01v8 ad=1.8 pd=7.2 as=0.9 ps=3.6 w=3 l=0.15
X14 sw3cs_0/a_n540_n5100# li_7680_n13980# a_8160_n13210# m2_3470_n16750# sky130_fd_pr__pfet_01v8 ad=3.6 pd=13.2 as=1.8 ps=6.6 w=6 l=0.15
X15 sw3cs_0/a_n540_n5100# li_7680_n13980# a_8160_n13210# m2_3470_n16750# sky130_fd_pr__pfet_01v8 ad=1.8 pd=6.6 as=1.8 ps=6.6 w=6 l=0.15
X16 a_8160_n13210# li_7680_n13980# sw3cs_0/a_n540_n5100# m2_3470_n16750# sky130_fd_pr__pfet_01v8 ad=1.8 pd=6.6 as=1.8 ps=6.6 w=6 l=0.15
X17 m2_4740_n7410# m1_7540_n14840# sw3cs_0/a_n260_n6040# gnd sky130_fd_pr__nfet_01v8 ad=3.6 pd=13.2 as=3.6 ps=13.2 w=6 l=0.15
X18 a_8160_n13210# li_7680_n13980# sw3cs_0/a_n540_n5100# m2_3470_n16750# sky130_fd_pr__pfet_01v8 ad=1.8 pd=6.6 as=1.8 ps=6.6 w=6 l=0.15
X19 m2_3470_n16750# sw3cs_0/a_n260_n6040# sw3cs_0/a_n540_n5100# m2_3470_n16750# sky130_fd_pr__pfet_01v8 ad=0.9 pd=3.6 as=1.8 ps=7.2 w=3 l=0.15
X20 m2_3470_n16750# m1_7540_n14840# sw3cs_0/a_n260_n6040# m2_3470_n16750# sky130_fd_pr__pfet_01v8 ad=1.2 pd=5.2 as=1.2 ps=5.2 w=2 l=0.15
X21 sw3cs_0/a_n540_n5100# li_7680_n13980# a_8160_n13210# m2_3470_n16750# sky130_fd_pr__pfet_01v8 ad=1.8 pd=6.6 as=3.6 ps=13.2 w=6 l=0.15
X22 sw3cs_0/a_n540_n5100# sw3cs_0/a_n260_n6040# m2_3470_n16750# m2_3470_n16750# sky130_fd_pr__pfet_01v8 ad=0.9 pd=3.6 as=0.9 ps=3.6 w=3 l=0.15
X23 li_5730_n12230# a_1120_n13160# 2nand1_0/a_160_n1540# gnd sky130_fd_pr__nfet_01v8 ad=3.5 pd=15 as=3.5 ps=15 w=7 l=0.4
X24 AND_0/Vdd a_1120_n13160# li_5730_n12230# AND_0/Vdd sky130_fd_pr__pfet_01v8 ad=4.9 pd=20.6 as=5.155 ps=19.2 w=9.8 l=0.4
X25 2nand1_0/a_160_n1540# a_5450_n12190# gnd gnd sky130_fd_pr__nfet_01v8 ad=3.5 pd=15 as=3.5 ps=15 w=7 l=0.4
X26 li_5730_n12230# a_5450_n12190# AND_0/Vdd AND_0/Vdd sky130_fd_pr__pfet_01v8 ad=5.155 pd=19.2 as=4.9 ps=20.6 w=9.8 l=0.4
X27 compnew_0/a_n542_2160# m4_11580_n10050# compnew_0/a_158_4380# AND_0/Vdd sky130_fd_pr__pfet_01v8 ad=6 pd=21.2 as=6 ps=21.2 w=10 l=0.15
X28 AND_0/b compnew_0/a_n202_2520# compnew_0/a_898_2120# AND_0/Vdd sky130_fd_pr__pfet_01v8 ad=2.6 pd=9.3 as=2.6 ps=9.3 w=4 l=0.4
X29 AND_0/Vdd compnew_0/a_n1102_2520# compnew_0/a_n1102_2520# AND_0/Vdd sky130_fd_pr__pfet_01v8 ad=0.6 pd=3.2 as=0.6 ps=3.2 w=1 l=0.2
X30 compnew_0/a_n122_5000# compnew_0/a_n122_5000# gnd gnd sky130_fd_pr__nfet_01v8 ad=3 pd=11.2 as=3 ps=11.2 w=5 l=0.15
X31 gnd compnew_0/a_n122_5000# compnew_0/a_n202_2520# gnd sky130_fd_pr__nfet_01v8 ad=3 pd=11.2 as=3 ps=11.2 w=5 l=0.15
X32 compnew_0/a_n982_2480# compnew_0/a_n982_2480# compnew_0/a_n1102_2520# AND_0/Vdd sky130_fd_pr__pfet_01v8 ad=1.8 pd=7.2 as=1.8 ps=7.2 w=3 l=0.2
X33 compnew_0/a_n422_2080# compnew_0/a_n82_2480# compnew_0/a_n202_2520# AND_0/Vdd sky130_fd_pr__pfet_01v8 ad=2.4 pd=9.2 as=2.4 ps=9.2 w=4 l=0.15
X34 compnew_0/a_n82_2480# compnew_0/a_158_4380# gnd gnd sky130_fd_pr__nfet_01v8 ad=1.2 pd=5.2 as=1.2 ps=5.2 w=2 l=0.2
X35 AND_0/Vdd compnew_0/a_n422_2080# compnew_0/a_n542_2160# AND_0/Vdd sky130_fd_pr__pfet_01v8 ad=4.8 pd=17.2 as=2.4 ps=8.6 w=8 l=0.15
X36 compnew_0/a_n422_2080# compnew_0/a_n422_2080# AND_0/Vdd AND_0/Vdd sky130_fd_pr__pfet_01v8 ad=0.6 pd=3.2 as=0.6 ps=3.2 w=1 l=0.15
X37 AND_0/Vdd compnew_0/a_n202_2520# compnew_0/a_898_2120# AND_0/Vdd sky130_fd_pr__pfet_01v8 ad=2.6 pd=9.3 as=2.6 ps=9.3 w=4 l=0.4
X38 gnd compnew_0/a_n1102_3300# compnew_0/a_n1102_3300# gnd sky130_fd_pr__nfet_01v8 ad=0.6 pd=3.2 as=0.6 ps=3.2 w=1 l=0.2
X39 gnd compnew_0/a_158_4380# compnew_0/a_158_4380# gnd sky130_fd_pr__nfet_01v8 ad=1.2 pd=5.2 as=1.2 ps=5.2 w=2 l=0.2
X40 compnew_0/a_n542_2160# compnew_0/a_n1102_2520# AND_0/Vdd AND_0/Vdd sky130_fd_pr__pfet_01v8 ad=2.4 pd=8.6 as=4.8 ps=17.2 w=8 l=0.15
X41 AND_0/b compnew_0/a_n202_2520# compnew_0/a_898_4180# gnd sky130_fd_pr__nfet_01v8 ad=1.3 pd=5.3 as=1.3 ps=5.3 w=2 l=0.4
X42 compnew_0/a_n122_5000# compnew_0/a_n122_5000# compnew_0/a_1538_2000# AND_0/Vdd sky130_fd_pr__pfet_01v8 ad=2.4 pd=9.2 as=2.4 ps=9.2 w=4 l=0.15
X43 gnd compnew_0/a_n202_2520# compnew_0/a_898_4180# gnd sky130_fd_pr__nfet_01v8 ad=1.3 pd=5.3 as=1.3 ps=5.3 w=2 l=0.4
X44 compnew_0/a_n982_2480# compnew_0/a_n982_2480# compnew_0/a_n1102_3300# gnd sky130_fd_pr__nfet_01v8 ad=0.6 pd=3.2 as=0.6 ps=3.2 w=1 l=0.2
X45 compnew_0/a_n82_2480# a_8160_n13210# compnew_0/a_n542_2160# AND_0/Vdd sky130_fd_pr__pfet_01v8 ad=6 pd=21.2 as=6 ps=21.2 w=10 l=0.15
X46 AND_0/Vdd compnew_0/a_1538_2000# compnew_0/a_1538_2000# AND_0/Vdd sky130_fd_pr__pfet_01v8 ad=2.4 pd=9.2 as=2.4 ps=9.2 w=4 l=0.15
X47 m2_4740_n7410# m1_7540_n11780# sw2cs_0/a_n920_2040# gnd sky130_fd_pr__nfet_01v8 ad=2.4 pd=9.2 as=2.4 ps=9.2 w=4 l=0.2
X48 AND_0/Vdd m1_7540_n11780# sw2cs_0/a_n920_2040# AND_0/Vdd sky130_fd_pr__pfet_01v8 ad=1.2 pd=5.2 as=1.2 ps=5.2 w=2 l=0.2
X49 sw2cs_0/a_n1040_2110# li_7690_n11680# a_8160_n13210# AND_0/Vdd sky130_fd_pr__pfet_01v8 ad=1.5 pd=6.2 as=0.75 ps=3.1 w=2.5 l=0.15
X50 AND_0/Vdd sw2cs_0/a_n920_2040# sw2cs_0/a_n1040_2110# AND_0/Vdd sky130_fd_pr__pfet_01v8 ad=1.23 pd=5.3 as=0.615 ps=2.65 w=2.05 l=0.15
X51 a_8160_n13210# li_7690_n11680# sw2cs_0/a_n1040_2110# AND_0/Vdd sky130_fd_pr__pfet_01v8 ad=0.75 pd=3.1 as=0.75 ps=3.1 w=2.5 l=0.15
X52 sw2cs_0/a_n1040_2110# li_7690_n11680# a_8160_n13210# AND_0/Vdd sky130_fd_pr__pfet_01v8 ad=0.75 pd=3.1 as=1.5 ps=6.2 w=2.5 l=0.15
X53 AND_0/Vdd sw2cs_0/a_n920_2040# sw2cs_0/a_n1040_2110# AND_0/Vdd sky130_fd_pr__pfet_01v8 ad=0.615 pd=2.65 as=1.23 ps=5.3 w=2.05 l=0.15
X54 sw2cs_0/a_n1040_2110# sw2cs_0/a_n920_2040# AND_0/Vdd AND_0/Vdd sky130_fd_pr__pfet_01v8 ad=0.615 pd=2.65 as=0.615 ps=2.65 w=2.05 l=0.15
X55 pulsedelay_0/a_998_460# pulsedelay_0/a_698_460# pulsedelay_0/a_868_n300# gnd sky130_fd_pr__nfet_01v8 ad=1 pd=5 as=1 ps=5 w=2 l=0.15
X56 pulsedelay_0/a_268_n300# m2_1930_n14060# gnd gnd sky130_fd_pr__nfet_01v8 ad=1.5 pd=7 as=1.5 ps=7 w=3 l=0.15
X57 gnd pulsedelay_0/a_268_n300# pulsedelay_0/a_268_n300# gnd sky130_fd_pr__nfet_01v8 ad=2.25 pd=10 as=2.25 ps=10 w=4.5 l=0.15
X58 pulsedelay_0/a_1468_n300# m2_1930_n14060# gnd gnd sky130_fd_pr__nfet_01v8 ad=1.5 pd=7 as=1.5 ps=7 w=3 l=0.15
X59 pulsedelay_0/a_998_460# pulsedelay_0/a_698_460# AND_0/Vdd AND_0/Vdd sky130_fd_pr__pfet_01v8 ad=2.5 pd=11 as=2.5 ps=11 w=5 l=0.15
X60 gnd pulsedelay_0/a_1468_n300# pulsedelay_0/a_1468_n300# gnd sky130_fd_pr__nfet_01v8 ad=2.25 pd=10 as=2.25 ps=10 w=4.5 l=0.15
X61 pulsedelay_0/a_1298_460# pulsedelay_0/a_998_460# gnd gnd sky130_fd_pr__nfet_01v8 ad=1 pd=5 as=1 ps=5 w=2 l=0.15
X62 pulsedelay_0/a_1298_460# pulsedelay_0/a_998_460# AND_0/Vdd AND_0/Vdd sky130_fd_pr__pfet_01v8 ad=2.5 pd=11 as=2.5 ps=11 w=5 l=0.15
X63 a_5450_n12190# pulsedelay_0/a_1298_460# pulsedelay_0/a_1468_n300# gnd sky130_fd_pr__nfet_01v8 ad=1 pd=5 as=1 ps=5 w=2 l=0.15
X64 pulsedelay_0/a_398_460# a_1120_n13160# AND_0/Vdd AND_0/Vdd sky130_fd_pr__pfet_01v8 ad=2.5 pd=11 as=2.5 ps=11 w=5 l=0.15
X65 pulsedelay_0/a_868_n300# m2_1930_n14060# gnd gnd sky130_fd_pr__nfet_01v8 ad=1.5 pd=7 as=1.5 ps=7 w=3 l=0.15
X66 gnd pulsedelay_0/a_868_n300# pulsedelay_0/a_868_n300# gnd sky130_fd_pr__nfet_01v8 ad=2.25 pd=10 as=2.25 ps=10 w=4.5 l=0.15
X67 a_5450_n12190# pulsedelay_0/a_1298_460# AND_0/Vdd AND_0/Vdd sky130_fd_pr__pfet_01v8 ad=2.5 pd=11 as=2.5 ps=11 w=5 l=0.15
X68 pulsedelay_0/a_698_460# pulsedelay_0/a_398_460# AND_0/Vdd AND_0/Vdd sky130_fd_pr__pfet_01v8 ad=2.5 pd=11 as=2.5 ps=11 w=5 l=0.15
X69 pulsedelay_0/a_398_460# a_1120_n13160# pulsedelay_0/a_268_n300# gnd sky130_fd_pr__nfet_01v8 ad=1 pd=5 as=1 ps=5 w=2 l=0.15
X70 pulsedelay_0/a_698_460# pulsedelay_0/a_398_460# gnd gnd sky130_fd_pr__nfet_01v8 ad=1 pd=5 as=1 ps=5 w=2 l=0.15
X71 pdvc_0/a_4840_n760# pdvc_0/a_6240_n800# m2_3470_n16750# m2_3470_n16750# sky130_fd_pr__pfet_01v8 ad=2.58 pd=9.8 as=2.58 ps=9.8 w=4.3 l=4
X72 pdvc_0/a_4840_n760# m2_1930_n14060# AND_0/b gnd sky130_fd_pr__nfet_01v8 ad=1.8 pd=7.2 as=1.8 ps=7.2 w=3 l=0.2
X73 AND_0/b AND_0/b gnd gnd sky130_fd_pr__nfet_01v8 ad=1.8 pd=7.2 as=1.8 ps=7.2 w=3 l=5
X74 m2_3470_n16750# pdvc_0/a_5140_n800# pdvc_0/a_4840_n760# m2_3470_n16750# sky130_fd_pr__pfet_01v8 ad=1.8 pd=7.2 as=1.8 ps=7.2 w=3 l=4
X75 pdvc_0/a_4840_n760# pdvc_0/a_4040_n800# m2_3470_n16750# m2_3470_n16750# sky130_fd_pr__pfet_01v8 ad=0.6 pd=3.2 as=0.6 ps=3.2 w=1 l=4
X76 m2_3470_n16750# pdvc_0/a_7340_n800# pdvc_0/a_4840_n760# m2_3470_n16750# sky130_fd_pr__pfet_01v8 ad=3.6 pd=13.2 as=3.6 ps=13.2 w=6 l=4
X77 counnew_0/a_290_16920# counnew_0/a_90_17580# counnew_0/a_130_16920# counnew_0/w_n6450_16080# sky130_fd_pr__pfet_01v8 ad=1.5 pd=6.2 as=0.75 ps=3.1 w=2.5 l=0.2
X78 counnew_0/a_8370_14580# counnew_0/w_n6450_16080# counnew_0/w_n6450_16080# counnew_0/w_n6450_16080# sky130_fd_pr__pfet_01v8 ad=0.45 pd=2.1 as=0.9 ps=4.2 w=1.5 l=0.3
X79 counnew_0/w_n6450_16080# counnew_0/a_n4290_15880# counnew_0/a_n4470_14580# counnew_0/w_n6450_16080# sky130_fd_pr__pfet_01v8 ad=0.45 pd=2.1 as=0.45 ps=2.1 w=1.5 l=0.3
X80 counnew_0/a_n1090_18480# counnew_0/a_n2910_18860# counnew_0/a_n6410_17820# counnew_0/a_n6410_17820# sky130_fd_pr__nfet_01v8 ad=0.21 pd=1.3 as=0.42 ps=2.6 w=0.7 l=0.2
X81 counnew_0/a_n6410_17820# counnew_0/a_750_16880# counnew_0/a_630_17820# counnew_0/a_n6410_17820# sky130_fd_pr__nfet_01v8 ad=0.6 pd=3.2 as=0.3 ps=1.6 w=1 l=0.2
X82 counnew_0/a_n6410_17820# counnew_0/a_n1390_16880# counnew_0/a_n1510_17820# counnew_0/a_n6410_17820# sky130_fd_pr__nfet_01v8 ad=0.6 pd=3.2 as=0.3 ps=1.6 w=1 l=0.2
X83 counnew_0/a_4190_13480# counnew_0/a_4270_15880# counnew_0/a_4370_12920# counnew_0/a_n6410_17820# sky130_fd_pr__nfet_01v8 ad=0.6 pd=3.2 as=0.3 ps=1.6 w=1 l=0.3
X84 counnew_0/a_1950_13340# a_12560_n12690# counnew_0/w_n6350_13440# counnew_0/w_n6350_13440# sky130_fd_pr__pfet_01v8 ad=0.9 pd=4.2 as=0.45 ps=2.1 w=1.5 l=0.3
X85 counnew_0/w_n6350_13440# counnew_0/a_2430_16920# counnew_0/a_2130_15880# counnew_0/w_n6350_13440# sky130_fd_pr__pfet_01v8 ad=0.45 pd=2.1 as=0.45 ps=2.1 w=1.5 l=0.3
X86 counnew_0/a_2050_14880# counnew_0/a_1950_14580# counnew_0/a_n6410_17820# counnew_0/a_n6410_17820# sky130_fd_pr__nfet_01v8 ad=0.3 pd=1.6 as=0.6 ps=3.2 w=1 l=0.3
X87 counnew_0/a_1950_14580# counnew_0/a_1950_13340# counnew_0/a_2230_15560# counnew_0/a_n6410_17820# sky130_fd_pr__nfet_01v8 ad=0.6 pd=3.2 as=0.3 ps=1.6 w=1 l=0.3
X88 counnew_0/a_4930_14220# a_12560_n12690# counnew_0/a_5110_14880# counnew_0/a_n6410_17820# sky130_fd_pr__nfet_01v8 ad=0.6 pd=3.2 as=0.3 ps=1.6 w=1 l=0.3
X89 counnew_0/a_4930_14220# counnew_0/a_4370_17580# counnew_0/w_n6350_13440# counnew_0/w_n6350_13440# sky130_fd_pr__pfet_01v8 ad=0.45 pd=2.1 as=0.9 ps=4.2 w=1.5 l=0.3
X90 counnew_0/a_8370_13340# a_12560_n12690# counnew_0/w_n6350_13440# counnew_0/w_n6350_13440# sky130_fd_pr__pfet_01v8 ad=0.9 pd=4.2 as=0.45 ps=2.1 w=1.5 l=0.3
X91 counnew_0/a_n4290_15880# counnew_0/a_n4370_13480# counnew_0/w_n6350_13440# counnew_0/w_n6350_13440# sky130_fd_pr__pfet_01v8 ad=0.45 pd=2.1 as=0.9 ps=4.2 w=1.5 l=0.3
X92 counnew_0/a_6330_14880# counnew_0/a_6230_14580# counnew_0/a_n6410_17820# counnew_0/a_n6410_17820# sky130_fd_pr__nfet_01v8 ad=0.3 pd=1.6 as=0.6 ps=3.2 w=1 l=0.3
X93 counnew_0/a_n250_16920# counnew_0/a_n770_18860# counnew_0/a_n6410_17820# counnew_0/a_n6410_17820# sky130_fd_pr__nfet_01v8 ad=0.6 pd=3.2 as=0.6 ps=3.2 w=1 l=0.2
X94 counnew_0/a_n6010_15880# a_12560_n12690# counnew_0/a_n5170_12920# counnew_0/a_n6410_17820# sky130_fd_pr__nfet_01v8 ad=0.6 pd=3.2 as=0.3 ps=1.6 w=1 l=0.3
X95 counnew_0/a_4930_15560# counnew_0/w_n6450_16080# counnew_0/a_n6410_17820# counnew_0/a_n6410_17820# sky130_fd_pr__nfet_01v8 ad=0.3 pd=1.6 as=0.6 ps=3.2 w=1 l=0.3
X96 counnew_0/a_8370_14580# counnew_0/a_8370_13340# counnew_0/a_8650_15560# counnew_0/a_n6410_17820# sky130_fd_pr__nfet_01v8 ad=0.6 pd=3.2 as=0.3 ps=1.6 w=1 l=0.3
X97 counnew_0/a_n5350_14880# counnew_0/a_n5910_17580# counnew_0/a_n6410_17820# counnew_0/a_n6410_17820# sky130_fd_pr__nfet_01v8 ad=0.3 pd=1.6 as=0.6 ps=3.2 w=1 l=0.3
X98 counnew_0/a_130_17820# counnew_0/a_90_17580# counnew_0/a_n6410_17820# counnew_0/a_n6410_17820# sky130_fd_pr__nfet_01v8 ad=0.3 pd=1.6 as=0.6 ps=3.2 w=1 l=0.2
X99 counnew_0/a_9210_14220# counnew_0/a_8650_17580# counnew_0/w_n6350_13440# counnew_0/w_n6350_13440# sky130_fd_pr__pfet_01v8 ad=0.45 pd=2.1 as=0.9 ps=4.2 w=1.5 l=0.3
X100 counnew_0/a_n4370_13480# counnew_0/a_n4290_15880# counnew_0/w_n6350_13440# counnew_0/w_n6350_13440# sky130_fd_pr__pfet_01v8 ad=0.9 pd=4.2 as=0.45 ps=2.1 w=1.5 l=0.3
X101 counnew_0/a_4570_16920# counnew_0/a_4370_17580# counnew_0/a_4410_16920# counnew_0/w_n6450_16080# sky130_fd_pr__pfet_01v8 ad=1.5 pd=6.2 as=0.75 ps=3.1 w=2.5 l=0.2
X102 counnew_0/a_9210_15560# counnew_0/w_n6450_16080# counnew_0/a_n6410_17820# counnew_0/a_n6410_17820# sky130_fd_pr__nfet_01v8 ad=0.3 pd=1.6 as=0.6 ps=3.2 w=1 l=0.3
X103 counnew_0/a_4370_12920# AND_0/out counnew_0/a_4190_12920# counnew_0/a_n6410_17820# sky130_fd_pr__nfet_01v8 ad=0.3 pd=1.6 as=0.3 ps=1.6 w=1 l=0.3
X104 counnew_0/a_n6190_14580# counnew_0/w_n6450_16080# counnew_0/w_n6450_16080# counnew_0/w_n6450_16080# sky130_fd_pr__pfet_01v8 ad=0.45 pd=2.1 as=0.9 ps=4.2 w=1.5 l=0.3
X105 counnew_0/a_n2150_15880# a_12560_n12690# counnew_0/a_n1310_12920# counnew_0/a_n6410_17820# sky130_fd_pr__nfet_01v8 ad=0.6 pd=3.2 as=0.3 ps=1.6 w=1 l=0.3
X106 counnew_0/a_n5710_16920# counnew_0/a_n5910_17580# counnew_0/a_n5870_16920# counnew_0/w_n6450_16080# sky130_fd_pr__pfet_01v8 ad=1.5 pd=6.2 as=0.75 ps=3.1 w=2.5 l=0.2
X107 counnew_0/a_1050_18860# counnew_0/a_n770_18860# counnew_0/w_n3430_18820# counnew_0/w_n3430_18820# sky130_fd_pr__pfet_01v8 ad=0.36 pd=1.8 as=0.72 ps=3.6 w=1.2 l=0.2
X108 counnew_0/a_n1490_14880# counnew_0/a_n2050_17580# counnew_0/a_n6410_17820# counnew_0/a_n6410_17820# sky130_fd_pr__nfet_01v8 ad=0.3 pd=1.6 as=0.6 ps=3.2 w=1 l=0.3
X109 counnew_0/a_n6410_17820# counnew_0/a_9310_16880# counnew_0/a_9190_17820# counnew_0/a_n6410_17820# sky130_fd_pr__nfet_01v8 ad=0.6 pd=3.2 as=0.3 ps=1.6 w=1 l=0.2
X110 counnew_0/w_n6350_13440# counnew_0/a_n3990_16920# counnew_0/a_n4290_15880# counnew_0/w_n6350_13440# sky130_fd_pr__pfet_01v8 ad=0.45 pd=2.1 as=0.45 ps=2.1 w=1.5 l=0.3
X111 counnew_0/w_n6450_16080# counnew_0/a_6410_15880# counnew_0/a_6230_14580# counnew_0/w_n6450_16080# sky130_fd_pr__pfet_01v8 ad=0.45 pd=2.1 as=0.45 ps=2.1 w=1.5 l=0.3
X112 counnew_0/a_n4470_13340# counnew_0/a_n4470_14580# counnew_0/w_n6350_13440# counnew_0/w_n6350_13440# sky130_fd_pr__pfet_01v8 ad=0.45 pd=2.1 as=0.9 ps=4.2 w=1.5 l=0.3
X113 counnew_0/a_7470_18860# counnew_0/a_5650_18860# counnew_0/w_n3430_18820# counnew_0/w_n3430_18820# sky130_fd_pr__pfet_01v8 ad=0.36 pd=1.8 as=0.72 ps=3.6 w=1.2 l=0.2
X114 counnew_0/a_n4370_15560# counnew_0/w_n6450_16080# counnew_0/a_n6410_17820# counnew_0/a_n6410_17820# sky130_fd_pr__nfet_01v8 ad=0.3 pd=1.6 as=0.6 ps=3.2 w=1 l=0.3
X115 counnew_0/a_n2330_14580# counnew_0/w_n6450_16080# counnew_0/w_n6450_16080# counnew_0/w_n6450_16080# sky130_fd_pr__pfet_01v8 ad=0.45 pd=2.1 as=0.9 ps=4.2 w=1.5 l=0.3
X116 counnew_0/a_n3230_18860# counnew_0/a_n5910_17580# counnew_0/w_n3430_18820# counnew_0/w_n3430_18820# sky130_fd_pr__pfet_01v8 ad=0.36 pd=1.8 as=0.72 ps=3.6 w=1.2 l=0.2
X117 counnew_0/a_650_12920# counnew_0/a_n90_13480# counnew_0/a_n6410_17820# counnew_0/a_n6410_17820# sky130_fd_pr__nfet_01v8 ad=0.3 pd=1.6 as=0.6 ps=3.2 w=1 l=0.3
X118 counnew_0/a_n1850_16920# counnew_0/a_n2050_17580# counnew_0/a_n2010_16920# counnew_0/w_n6450_16080# sky130_fd_pr__pfet_01v8 ad=1.5 pd=6.2 as=0.75 ps=3.1 w=2.5 l=0.2
X119 counnew_0/a_650_14220# a_12560_n12690# counnew_0/a_830_14880# counnew_0/a_n6410_17820# sky130_fd_pr__nfet_01v8 ad=0.6 pd=3.2 as=0.3 ps=1.6 w=1 l=0.3
X120 counnew_0/a_2050_13480# counnew_0/a_1950_13340# counnew_0/w_n6350_13440# counnew_0/w_n6350_13440# sky130_fd_pr__pfet_01v8 ad=0.45 pd=2.1 as=0.9 ps=4.2 w=1.5 l=0.3
X121 counnew_0/a_n190_14580# counnew_0/w_n6450_16080# counnew_0/w_n6450_16080# counnew_0/w_n6450_16080# sky130_fd_pr__pfet_01v8 ad=0.45 pd=2.1 as=0.9 ps=4.2 w=1.5 l=0.3
X122 counnew_0/a_4270_15880# a_12560_n12690# counnew_0/w_n6350_13440# counnew_0/w_n6350_13440# sky130_fd_pr__pfet_01v8 ad=0.9 pd=4.2 as=0.45 ps=2.1 w=1.5 l=0.3
X123 counnew_0/a_6330_13480# counnew_0/a_6230_13340# counnew_0/w_n6350_13440# counnew_0/w_n6350_13440# sky130_fd_pr__pfet_01v8 ad=0.45 pd=2.1 as=0.9 ps=4.2 w=1.5 l=0.3
X124 counnew_0/w_n6450_16080# counnew_0/a_90_17580# counnew_0/a_750_16880# counnew_0/w_n6450_16080# sky130_fd_pr__pfet_01v8 ad=1.5 pd=6.2 as=1.5 ps=6.2 w=2.5 l=0.2
X125 counnew_0/w_n6350_13440# counnew_0/a_6330_13480# counnew_0/a_7070_14220# counnew_0/w_n6350_13440# sky130_fd_pr__pfet_01v8 ad=0.45 pd=2.1 as=0.45 ps=2.1 w=1.5 l=0.3
X126 counnew_0/a_n6010_15880# counnew_0/a_n6090_13480# counnew_0/w_n6350_13440# counnew_0/w_n6350_13440# sky130_fd_pr__pfet_01v8 ad=0.45 pd=2.1 as=0.9 ps=4.2 w=1.5 l=0.3
X127 counnew_0/w_n6450_16080# counnew_0/a_n2150_15880# counnew_0/a_n2330_14580# counnew_0/w_n6450_16080# sky130_fd_pr__pfet_01v8 ad=0.45 pd=2.1 as=0.45 ps=2.1 w=1.5 l=0.3
X128 counnew_0/a_7250_15560# counnew_0/a_6230_13340# counnew_0/a_7070_15560# counnew_0/a_n6410_17820# sky130_fd_pr__nfet_01v8 ad=0.3 pd=1.6 as=0.3 ps=1.6 w=1 l=0.3
X129 counnew_0/a_2050_13480# counnew_0/a_2130_15880# counnew_0/a_2230_12920# counnew_0/a_n6410_17820# sky130_fd_pr__nfet_01v8 ad=0.6 pd=3.2 as=0.3 ps=1.6 w=1 l=0.3
X130 counnew_0/a_n5910_14880# AND_0/out counnew_0/a_n6090_14880# counnew_0/a_n6410_17820# sky130_fd_pr__nfet_01v8 ad=0.3 pd=1.6 as=0.3 ps=1.6 w=1 l=0.3
X131 counnew_0/a_n4150_17820# counnew_0/a_n4190_17580# counnew_0/a_n6410_17820# counnew_0/a_n6410_17820# sky130_fd_pr__nfet_01v8 ad=0.3 pd=1.6 as=0.6 ps=3.2 w=1 l=0.2
X132 counnew_0/a_4930_12920# counnew_0/a_4190_13480# counnew_0/a_n6410_17820# counnew_0/a_n6410_17820# sky130_fd_pr__nfet_01v8 ad=0.3 pd=1.6 as=0.6 ps=3.2 w=1 l=0.3
X133 counnew_0/a_8470_13480# counnew_0/a_8550_15880# counnew_0/a_8650_12920# counnew_0/a_n6410_17820# sky130_fd_pr__nfet_01v8 ad=0.6 pd=3.2 as=0.3 ps=1.6 w=1 l=0.3
X134 counnew_0/a_2790_14220# counnew_0/a_2230_17580# counnew_0/w_n6350_13440# counnew_0/w_n6350_13440# sky130_fd_pr__pfet_01v8 ad=0.45 pd=2.1 as=0.9 ps=4.2 w=1.5 l=0.3
X135 counnew_0/a_6230_13340# a_12560_n12690# counnew_0/w_n6350_13440# counnew_0/w_n6350_13440# sky130_fd_pr__pfet_01v8 ad=0.9 pd=4.2 as=0.45 ps=2.1 w=1.5 l=0.3
X136 counnew_0/a_n2150_15880# counnew_0/a_n2230_13480# counnew_0/w_n6350_13440# counnew_0/w_n6350_13440# sky130_fd_pr__pfet_01v8 ad=0.45 pd=2.1 as=0.9 ps=4.2 w=1.5 l=0.3
X137 counnew_0/a_4190_14880# counnew_0/a_4090_14580# counnew_0/a_n6410_17820# counnew_0/a_n6410_17820# sky130_fd_pr__nfet_01v8 ad=0.3 pd=1.6 as=0.6 ps=3.2 w=1 l=0.3
X138 counnew_0/a_2790_15560# counnew_0/w_n6450_16080# counnew_0/a_n6410_17820# counnew_0/a_n6410_17820# sky130_fd_pr__nfet_01v8 ad=0.3 pd=1.6 as=0.6 ps=3.2 w=1 l=0.3
X139 counnew_0/a_6230_14580# counnew_0/a_6230_13340# counnew_0/a_6510_15560# counnew_0/a_n6410_17820# sky130_fd_pr__nfet_01v8 ad=0.6 pd=3.2 as=0.3 ps=1.6 w=1 l=0.3
X140 counnew_0/a_4090_14580# counnew_0/a_4090_13340# counnew_0/w_n6450_16080# counnew_0/w_n6450_16080# sky130_fd_pr__pfet_01v8 ad=0.9 pd=4.2 as=0.45 ps=2.1 w=1.5 l=0.3
X141 counnew_0/a_9210_12920# counnew_0/a_8470_13480# counnew_0/a_n6410_17820# counnew_0/a_n6410_17820# sky130_fd_pr__nfet_01v8 ad=0.3 pd=1.6 as=0.6 ps=3.2 w=1 l=0.3
X142 counnew_0/a_n6410_17820# counnew_0/a_n4190_17580# counnew_0/a_n3530_16880# counnew_0/a_n6410_17820# sky130_fd_pr__nfet_01v8 ad=0.6 pd=3.2 as=0.6 ps=3.2 w=1 l=0.2
X143 counnew_0/a_7070_14220# counnew_0/a_6510_17580# counnew_0/w_n6350_13440# counnew_0/w_n6350_13440# sky130_fd_pr__pfet_01v8 ad=0.45 pd=2.1 as=0.9 ps=4.2 w=1.5 l=0.3
X144 counnew_0/a_9210_14220# a_12560_n12690# counnew_0/a_9390_14880# counnew_0/a_n6410_17820# sky130_fd_pr__nfet_01v8 ad=0.6 pd=3.2 as=0.3 ps=1.6 w=1 l=0.3
X145 counnew_0/a_7070_15560# counnew_0/w_n6450_16080# counnew_0/a_n6410_17820# counnew_0/a_n6410_17820# sky130_fd_pr__nfet_01v8 ad=0.3 pd=1.6 as=0.6 ps=3.2 w=1 l=0.3
X146 counnew_0/a_n5910_17580# counnew_0/a_n5350_14220# counnew_0/w_n6450_16080# counnew_0/w_n6450_16080# sky130_fd_pr__pfet_01v8 ad=0.9 pd=4.2 as=0.45 ps=2.1 w=1.5 l=0.3
X147 counnew_0/a_n10_15880# a_12560_n12690# counnew_0/w_n6350_13440# counnew_0/w_n6350_13440# sky130_fd_pr__pfet_01v8 ad=0.9 pd=4.2 as=0.45 ps=2.1 w=1.5 l=0.3
X148 counnew_0/a_8850_16920# counnew_0/a_8650_17580# counnew_0/a_8690_16920# counnew_0/w_n6450_16080# sky130_fd_pr__pfet_01v8 ad=1.5 pd=6.2 as=0.75 ps=3.1 w=2.5 l=0.2
X149 counnew_0/a_n4370_12920# counnew_0/a_n4470_13340# counnew_0/a_n6410_17820# counnew_0/a_n6410_17820# sky130_fd_pr__nfet_01v8 ad=0.3 pd=1.6 as=0.6 ps=3.2 w=1 l=0.3
X150 counnew_0/w_n6450_16080# counnew_0/a_4270_15880# counnew_0/a_4090_14580# counnew_0/w_n6450_16080# sky130_fd_pr__pfet_01v8 ad=0.45 pd=2.1 as=0.45 ps=2.1 w=1.5 l=0.3
X151 counnew_0/a_n3630_14220# a_12560_n12690# counnew_0/w_n6350_13440# counnew_0/w_n6350_13440# sky130_fd_pr__pfet_01v8 ad=0.9 pd=4.2 as=0.45 ps=2.1 w=1.5 l=0.3
X152 counnew_0/a_n2330_13340# a_12560_n12690# counnew_0/a_n2050_14880# counnew_0/a_n6410_17820# sky130_fd_pr__nfet_01v8 ad=0.6 pd=3.2 as=0.3 ps=1.6 w=1 l=0.3
X153 counnew_0/a_n4190_17580# counnew_0/a_n3630_14220# counnew_0/a_n3450_15560# counnew_0/a_n6410_17820# sky130_fd_pr__nfet_01v8 ad=0.6 pd=3.2 as=0.3 ps=1.6 w=1 l=0.3
X154 counnew_0/a_n1090_18860# counnew_0/a_n2910_18860# counnew_0/w_n3430_18820# counnew_0/w_n3430_18820# sky130_fd_pr__pfet_01v8 ad=0.36 pd=1.8 as=0.72 ps=3.6 w=1.2 l=0.2
X155 counnew_0/a_n2050_17580# counnew_0/a_n1490_14220# counnew_0/w_n6450_16080# counnew_0/w_n6450_16080# sky130_fd_pr__pfet_01v8 ad=0.9 pd=4.2 as=0.45 ps=2.1 w=1.5 l=0.3
X156 counnew_0/a_3510_18860# counnew_0/a_3190_18860# counnew_0/w_n3430_18820# counnew_0/w_n3430_18820# sky130_fd_pr__pfet_01v8 ad=0.72 pd=3.6 as=0.36 ps=1.8 w=1.2 l=0.2
X157 counnew_0/a_n190_13340# a_12560_n12690# counnew_0/w_n6350_13440# counnew_0/w_n6350_13440# sky130_fd_pr__pfet_01v8 ad=0.9 pd=4.2 as=0.45 ps=2.1 w=1.5 l=0.3
X158 counnew_0/w_n6350_13440# AND_0/out counnew_0/a_n6090_13480# counnew_0/w_n6350_13440# sky130_fd_pr__pfet_01v8 ad=0.45 pd=2.1 as=0.45 ps=2.1 w=1.5 l=0.3
X159 counnew_0/a_5650_18860# counnew_0/a_5330_18860# counnew_0/a_n6410_17820# counnew_0/a_n6410_17820# sky130_fd_pr__nfet_01v8 ad=0.42 pd=2.6 as=0.42 ps=2.6 w=0.7 l=0.2
X160 counnew_0/a_n190_14580# counnew_0/a_n190_13340# counnew_0/a_90_15560# counnew_0/a_n6410_17820# sky130_fd_pr__nfet_01v8 ad=0.6 pd=3.2 as=0.3 ps=1.6 w=1 l=0.3
X161 counnew_0/a_n3990_16920# counnew_0/a_n4190_17580# counnew_0/a_n4150_16920# counnew_0/w_n6450_16080# sky130_fd_pr__pfet_01v8 ad=1.5 pd=6.2 as=0.75 ps=3.1 w=2.5 l=0.2
X162 counnew_0/a_2230_14880# AND_0/out counnew_0/a_2050_14880# counnew_0/a_n6410_17820# sky130_fd_pr__nfet_01v8 ad=0.3 pd=1.6 as=0.3 ps=1.6 w=1 l=0.3
X163 counnew_0/a_4190_13480# counnew_0/a_4090_13340# counnew_0/w_n6350_13440# counnew_0/w_n6350_13440# sky130_fd_pr__pfet_01v8 ad=0.45 pd=2.1 as=0.9 ps=4.2 w=1.5 l=0.3
X164 counnew_0/a_7250_12920# counnew_0/a_6710_16920# counnew_0/a_7070_12920# counnew_0/a_n6410_17820# sky130_fd_pr__nfet_01v8 ad=0.3 pd=1.6 as=0.3 ps=1.6 w=1 l=0.3
X165 counnew_0/a_630_17820# counnew_0/a_n250_16920# counnew_0/a_290_16920# counnew_0/a_n6410_17820# sky130_fd_pr__nfet_01v8 ad=0.3 pd=1.6 as=0.6 ps=3.2 w=1 l=0.2
X166 counnew_0/w_n6350_13440# counnew_0/a_4190_13480# counnew_0/a_4930_14220# counnew_0/w_n6350_13440# sky130_fd_pr__pfet_01v8 ad=0.45 pd=2.1 as=0.45 ps=2.1 w=1.5 l=0.3
X167 counnew_0/a_90_17580# counnew_0/w_n6450_16080# counnew_0/w_n6450_16080# counnew_0/w_n6450_16080# sky130_fd_pr__pfet_01v8 ad=0.45 pd=2.1 as=0.9 ps=4.2 w=1.5 l=0.3
X168 counnew_0/a_n3650_16920# counnew_0/a_n5910_17580# counnew_0/a_n3990_16920# counnew_0/w_n6450_16080# sky130_fd_pr__pfet_01v8 ad=0.75 pd=3.1 as=1.5 ps=6.2 w=2.5 l=0.2
X169 counnew_0/a_8550_15880# a_12560_n12690# counnew_0/w_n6350_13440# counnew_0/w_n6350_13440# sky130_fd_pr__pfet_01v8 ad=0.9 pd=4.2 as=0.45 ps=2.1 w=1.5 l=0.3
X170 counnew_0/a_5110_15560# counnew_0/a_4090_13340# counnew_0/a_4930_15560# counnew_0/a_n6410_17820# sky130_fd_pr__nfet_01v8 ad=0.3 pd=1.6 as=0.3 ps=1.6 w=1 l=0.3
X171 counnew_0/a_8650_14880# AND_0/out counnew_0/a_8470_14880# counnew_0/a_n6410_17820# sky130_fd_pr__nfet_01v8 ad=0.3 pd=1.6 as=0.3 ps=1.6 w=1 l=0.3
X172 counnew_0/w_n6450_16080# counnew_0/a_4370_17580# counnew_0/a_5030_16880# counnew_0/w_n6450_16080# sky130_fd_pr__pfet_01v8 ad=1.5 pd=6.2 as=1.5 ps=6.2 w=2.5 l=0.2
X173 counnew_0/w_n6350_13440# counnew_0/a_n6090_13480# counnew_0/a_n5350_14220# counnew_0/w_n6350_13440# sky130_fd_pr__pfet_01v8 ad=0.45 pd=2.1 as=0.45 ps=2.1 w=1.5 l=0.3
X174 counnew_0/a_n2010_17820# counnew_0/a_n2050_17580# counnew_0/a_n6410_17820# counnew_0/a_n6410_17820# sky130_fd_pr__nfet_01v8 ad=0.3 pd=1.6 as=0.6 ps=3.2 w=1 l=0.2
X175 counnew_0/a_n5170_15560# counnew_0/a_n6190_13340# counnew_0/a_n5350_15560# counnew_0/a_n6410_17820# sky130_fd_pr__nfet_01v8 ad=0.3 pd=1.6 as=0.3 ps=1.6 w=1 l=0.3
X176 counnew_0/a_n1090_18860# counnew_0/a_n2050_17580# counnew_0/a_n1090_18480# counnew_0/a_n6410_17820# sky130_fd_pr__nfet_01v8 ad=0.42 pd=2.6 as=0.21 ps=1.3 w=0.7 l=0.2
X177 counnew_0/a_n6410_17820# counnew_0/a_n3530_16880# counnew_0/a_n3650_17820# counnew_0/a_n6410_17820# sky130_fd_pr__nfet_01v8 ad=0.6 pd=3.2 as=0.3 ps=1.6 w=1 l=0.2
X178 counnew_0/a_2790_12920# counnew_0/a_2050_13480# counnew_0/a_n6410_17820# counnew_0/a_n6410_17820# sky130_fd_pr__nfet_01v8 ad=0.3 pd=1.6 as=0.6 ps=3.2 w=1 l=0.3
X179 counnew_0/a_6330_13480# counnew_0/a_6410_15880# counnew_0/a_6510_12920# counnew_0/a_n6410_17820# sky130_fd_pr__nfet_01v8 ad=0.6 pd=3.2 as=0.3 ps=1.6 w=1 l=0.3
X180 counnew_0/a_4030_16920# counnew_0/a_3510_18860# counnew_0/w_n6450_16080# counnew_0/w_n6450_16080# sky130_fd_pr__pfet_01v8 ad=1.5 pd=6.2 as=1.5 ps=6.2 w=2.5 l=0.2
X181 counnew_0/a_n4530_16920# counnew_0/a_n5910_17580# counnew_0/a_n6410_17820# counnew_0/a_n6410_17820# sky130_fd_pr__nfet_01v8 ad=0.6 pd=3.2 as=0.6 ps=3.2 w=1 l=0.2
X182 counnew_0/a_1950_14580# counnew_0/a_1950_13340# counnew_0/w_n6450_16080# counnew_0/w_n6450_16080# sky130_fd_pr__pfet_01v8 ad=0.9 pd=4.2 as=0.45 ps=2.1 w=1.5 l=0.3
X183 counnew_0/a_7070_12920# counnew_0/a_6330_13480# counnew_0/a_n6410_17820# counnew_0/a_n6410_17820# sky130_fd_pr__nfet_01v8 ad=0.3 pd=1.6 as=0.6 ps=3.2 w=1 l=0.3
X184 counnew_0/a_8310_16920# counnew_0/a_7790_18860# counnew_0/w_n6450_16080# counnew_0/w_n6450_16080# sky130_fd_pr__pfet_01v8 ad=1.5 pd=6.2 as=1.5 ps=6.2 w=2.5 l=0.2
X185 counnew_0/a_4410_16920# counnew_0/a_4030_16920# counnew_0/w_n6450_16080# counnew_0/w_n6450_16080# sky130_fd_pr__pfet_01v8 ad=0.75 pd=3.1 as=1.5 ps=6.2 w=2.5 l=0.2
X186 counnew_0/a_n6410_17820# counnew_0/a_n2050_17580# counnew_0/a_n1390_16880# counnew_0/a_n6410_17820# sky130_fd_pr__nfet_01v8 ad=0.6 pd=3.2 as=0.6 ps=3.2 w=1 l=0.2
X187 counnew_0/w_n6350_13440# counnew_0/a_n2230_13480# counnew_0/a_n1490_14220# counnew_0/w_n6350_13440# sky130_fd_pr__pfet_01v8 ad=0.45 pd=2.1 as=0.45 ps=2.1 w=1.5 l=0.3
X188 counnew_0/w_n6350_13440# AND_0/out counnew_0/a_n190_13340# counnew_0/w_n6350_13440# sky130_fd_pr__pfet_01v8 ad=0.45 pd=2.1 as=0.45 ps=2.1 w=1.5 l=0.3
X189 counnew_0/a_n2230_13480# counnew_0/a_n2150_15880# counnew_0/w_n6350_13440# counnew_0/w_n6350_13440# sky130_fd_pr__pfet_01v8 ad=0.9 pd=4.2 as=0.45 ps=2.1 w=1.5 l=0.3
X190 counnew_0/a_8470_14880# counnew_0/a_8370_14580# counnew_0/a_n6410_17820# counnew_0/a_n6410_17820# sky130_fd_pr__nfet_01v8 ad=0.3 pd=1.6 as=0.6 ps=3.2 w=1 l=0.3
X191 counnew_0/a_n1310_15560# counnew_0/a_n2330_13340# counnew_0/a_n1490_15560# counnew_0/a_n6410_17820# sky130_fd_pr__nfet_01v8 ad=0.3 pd=1.6 as=0.3 ps=1.6 w=1 l=0.3
X192 counnew_0/a_4910_17820# counnew_0/a_4030_16920# counnew_0/a_4570_16920# counnew_0/a_n6410_17820# sky130_fd_pr__nfet_01v8 ad=0.3 pd=1.6 as=0.6 ps=3.2 w=1 l=0.2
X193 counnew_0/a_90_15560# counnew_0/a_n10_15880# counnew_0/a_n90_15560# counnew_0/a_n6410_17820# sky130_fd_pr__nfet_01v8 ad=0.3 pd=1.6 as=0.3 ps=1.6 w=1 l=0.3
X194 counnew_0/a_8370_14580# counnew_0/a_8370_13340# counnew_0/w_n6450_16080# counnew_0/w_n6450_16080# sky130_fd_pr__pfet_01v8 ad=0.9 pd=4.2 as=0.45 ps=2.1 w=1.5 l=0.3
X195 counnew_0/a_4370_17580# counnew_0/w_n6450_16080# counnew_0/w_n6450_16080# counnew_0/w_n6450_16080# sky130_fd_pr__pfet_01v8 ad=0.45 pd=2.1 as=0.9 ps=4.2 w=1.5 l=0.3
X196 counnew_0/a_n4190_14880# AND_0/out counnew_0/a_n4370_14880# counnew_0/a_n6410_17820# sky130_fd_pr__nfet_01v8 ad=0.3 pd=1.6 as=0.3 ps=1.6 w=1 l=0.3
X197 counnew_0/a_8650_17580# counnew_0/w_n6450_16080# counnew_0/w_n6450_16080# counnew_0/w_n6450_16080# sky130_fd_pr__pfet_01v8 ad=0.45 pd=2.1 as=0.9 ps=4.2 w=1.5 l=0.3
X198 counnew_0/a_9190_17820# counnew_0/a_8310_16920# counnew_0/a_8850_16920# counnew_0/a_n6410_17820# sky130_fd_pr__nfet_01v8 ad=0.3 pd=1.6 as=0.6 ps=3.2 w=1 l=0.2
X199 counnew_0/a_2430_16920# counnew_0/a_1370_18860# counnew_0/a_2270_17820# counnew_0/a_n6410_17820# sky130_fd_pr__nfet_01v8 ad=0.6 pd=3.2 as=0.3 ps=1.6 w=1 l=0.2
X200 counnew_0/w_n6350_13440# counnew_0/a_n90_13480# counnew_0/a_650_14220# counnew_0/w_n6350_13440# sky130_fd_pr__pfet_01v8 ad=0.45 pd=2.1 as=0.45 ps=2.1 w=1.5 l=0.3
X201 counnew_0/w_n6350_13440# AND_0/out counnew_0/a_2050_13480# counnew_0/w_n6350_13440# sky130_fd_pr__pfet_01v8 ad=0.45 pd=2.1 as=0.45 ps=2.1 w=1.5 l=0.3
X202 counnew_0/a_n4290_15880# a_12560_n12690# counnew_0/a_n3450_12920# counnew_0/a_n6410_17820# sky130_fd_pr__nfet_01v8 ad=0.6 pd=3.2 as=0.3 ps=1.6 w=1 l=0.3
X203 counnew_0/a_2790_14220# a_12560_n12690# counnew_0/w_n6350_13440# counnew_0/w_n6350_13440# sky130_fd_pr__pfet_01v8 ad=0.9 pd=4.2 as=0.45 ps=2.1 w=1.5 l=0.3
X204 counnew_0/a_830_15560# counnew_0/a_n190_13340# counnew_0/a_650_15560# counnew_0/a_n6410_17820# sky130_fd_pr__nfet_01v8 ad=0.3 pd=1.6 as=0.3 ps=1.6 w=1 l=0.3
X205 counnew_0/a_2230_17580# counnew_0/a_2790_14220# counnew_0/a_2970_15560# counnew_0/a_n6410_17820# sky130_fd_pr__nfet_01v8 ad=0.6 pd=3.2 as=0.3 ps=1.6 w=1 l=0.3
X206 counnew_0/a_1370_18860# counnew_0/a_1050_18860# counnew_0/w_n3430_18820# counnew_0/w_n3430_18820# sky130_fd_pr__pfet_01v8 ad=0.72 pd=3.6 as=0.36 ps=1.8 w=1.2 l=0.2
X207 counnew_0/w_n6350_13440# AND_0/out counnew_0/a_8470_13480# counnew_0/w_n6350_13440# sky130_fd_pr__pfet_01v8 ad=0.45 pd=2.1 as=0.45 ps=2.1 w=1.5 l=0.3
X208 counnew_0/a_n90_13480# counnew_0/a_n10_15880# counnew_0/a_90_12920# counnew_0/a_n6410_17820# sky130_fd_pr__nfet_01v8 ad=0.6 pd=3.2 as=0.3 ps=1.6 w=1 l=0.3
X209 counnew_0/a_n5370_16920# counnew_0/w_n6450_16080# counnew_0/a_n5710_16920# counnew_0/w_n6450_16080# sky130_fd_pr__pfet_01v8 ad=0.75 pd=3.1 as=1.5 ps=6.2 w=2.5 l=0.2
X210 counnew_0/a_n4470_14580# counnew_0/w_n6450_16080# counnew_0/w_n6450_16080# counnew_0/w_n6450_16080# sky130_fd_pr__pfet_01v8 ad=0.45 pd=2.1 as=0.9 ps=4.2 w=1.5 l=0.3
X211 counnew_0/a_3510_18860# counnew_0/a_3190_18860# counnew_0/a_n6410_17820# counnew_0/a_n6410_17820# sky130_fd_pr__nfet_01v8 ad=0.42 pd=2.6 as=0.42 ps=2.6 w=0.7 l=0.2
X212 counnew_0/a_n6090_14880# counnew_0/a_n6190_14580# counnew_0/a_n6410_17820# counnew_0/a_n6410_17820# sky130_fd_pr__nfet_01v8 ad=0.3 pd=1.6 as=0.6 ps=3.2 w=1 l=0.3
X213 counnew_0/a_7790_18860# counnew_0/a_7470_18860# counnew_0/w_n3430_18820# counnew_0/w_n3430_18820# sky130_fd_pr__pfet_01v8 ad=0.72 pd=3.6 as=0.36 ps=1.8 w=1.2 l=0.2
X214 counnew_0/a_n5870_17820# counnew_0/a_n5910_17580# counnew_0/a_n6410_17820# counnew_0/a_n6410_17820# sky130_fd_pr__nfet_01v8 ad=0.3 pd=1.6 as=0.6 ps=3.2 w=1 l=0.2
X215 counnew_0/a_n6190_13340# a_12560_n12690# counnew_0/w_n6350_13440# counnew_0/w_n6350_13440# sky130_fd_pr__pfet_01v8 ad=0.9 pd=4.2 as=0.45 ps=2.1 w=1.5 l=0.3
X216 counnew_0/a_5110_12920# counnew_0/a_4570_16920# counnew_0/a_4930_12920# counnew_0/a_n6410_17820# sky130_fd_pr__nfet_01v8 ad=0.3 pd=1.6 as=0.3 ps=1.6 w=1 l=0.3
X217 counnew_0/a_n6190_14580# counnew_0/a_n6190_13340# counnew_0/a_n5910_15560# counnew_0/a_n6410_17820# sky130_fd_pr__nfet_01v8 ad=0.6 pd=3.2 as=0.3 ps=1.6 w=1 l=0.3
X218 counnew_0/a_1050_18860# counnew_0/a_90_17580# counnew_0/a_1050_18480# counnew_0/a_n6410_17820# sky130_fd_pr__nfet_01v8 ad=0.42 pd=2.6 as=0.21 ps=1.3 w=0.7 l=0.2
X219 counnew_0/a_n1510_16920# counnew_0/a_n2910_18860# counnew_0/a_n1850_16920# counnew_0/w_n6450_16080# sky130_fd_pr__pfet_01v8 ad=0.75 pd=3.1 as=1.5 ps=6.2 w=2.5 l=0.2
X220 counnew_0/a_6510_14880# AND_0/out counnew_0/a_6330_14880# counnew_0/a_n6410_17820# sky130_fd_pr__nfet_01v8 ad=0.3 pd=1.6 as=0.3 ps=1.6 w=1 l=0.3
X221 counnew_0/a_n5170_12920# counnew_0/a_n5710_16920# counnew_0/a_n5350_12920# counnew_0/a_n6410_17820# sky130_fd_pr__nfet_01v8 ad=0.3 pd=1.6 as=0.3 ps=1.6 w=1 l=0.3
X222 counnew_0/a_8470_13480# counnew_0/a_8370_13340# counnew_0/w_n6350_13440# counnew_0/w_n6350_13440# sky130_fd_pr__pfet_01v8 ad=0.45 pd=2.1 as=0.9 ps=4.2 w=1.5 l=0.3
X223 counnew_0/w_n6450_16080# counnew_0/a_2230_17580# counnew_0/a_2890_16880# counnew_0/w_n6450_16080# sky130_fd_pr__pfet_01v8 ad=1.5 pd=6.2 as=1.5 ps=6.2 w=2.5 l=0.2
X224 counnew_0/a_n6410_17820# counnew_0/a_n5910_17580# counnew_0/a_n5250_16880# counnew_0/a_n6410_17820# sky130_fd_pr__nfet_01v8 ad=0.6 pd=3.2 as=0.6 ps=3.2 w=1 l=0.2
X225 counnew_0/a_7470_18860# counnew_0/a_6510_17580# counnew_0/a_7470_18480# counnew_0/a_n6410_17820# sky130_fd_pr__nfet_01v8 ad=0.42 pd=2.6 as=0.21 ps=1.3 w=0.7 l=0.2
X226 counnew_0/w_n6350_13440# counnew_0/a_8470_13480# counnew_0/a_9210_14220# counnew_0/w_n6350_13440# sky130_fd_pr__pfet_01v8 ad=0.45 pd=2.1 as=0.45 ps=2.1 w=1.5 l=0.3
X227 counnew_0/a_n2230_14880# counnew_0/a_n2330_14580# counnew_0/a_n6410_17820# counnew_0/a_n6410_17820# sky130_fd_pr__nfet_01v8 ad=0.3 pd=1.6 as=0.6 ps=3.2 w=1 l=0.3
X228 counnew_0/w_n6350_13440# AND_0/out counnew_0/a_n4370_13480# counnew_0/w_n6350_13440# sky130_fd_pr__pfet_01v8 ad=0.45 pd=2.1 as=0.45 ps=2.1 w=1.5 l=0.3
X229 counnew_0/a_9390_15560# counnew_0/a_8370_13340# counnew_0/a_9210_15560# counnew_0/a_n6410_17820# sky130_fd_pr__nfet_01v8 ad=0.3 pd=1.6 as=0.3 ps=1.6 w=1 l=0.3
X230 counnew_0/w_n6450_16080# counnew_0/a_6230_13340# counnew_0/a_6510_17580# counnew_0/w_n6450_16080# sky130_fd_pr__pfet_01v8 ad=0.45 pd=2.1 as=0.45 ps=2.1 w=1.5 l=0.3
X231 counnew_0/a_1890_16920# counnew_0/a_1370_18860# counnew_0/w_n6450_16080# counnew_0/w_n6450_16080# sky130_fd_pr__pfet_01v8 ad=1.5 pd=6.2 as=1.5 ps=6.2 w=2.5 l=0.2
X232 counnew_0/a_n2390_16920# counnew_0/a_n2910_18860# counnew_0/a_n6410_17820# counnew_0/a_n6410_17820# sky130_fd_pr__nfet_01v8 ad=0.6 pd=3.2 as=0.6 ps=3.2 w=1 l=0.2
X233 counnew_0/w_n6450_16080# counnew_0/a_8650_17580# counnew_0/a_9310_16880# counnew_0/w_n6450_16080# sky130_fd_pr__pfet_01v8 ad=1.5 pd=6.2 as=1.5 ps=6.2 w=2.5 l=0.2
X234 counnew_0/w_n6450_16080# counnew_0/a_2890_16880# counnew_0/a_2770_16920# counnew_0/w_n6450_16080# sky130_fd_pr__pfet_01v8 ad=1.5 pd=6.2 as=0.75 ps=3.1 w=2.5 l=0.2
X235 counnew_0/a_n90_14880# counnew_0/a_n190_14580# counnew_0/a_n6410_17820# counnew_0/a_n6410_17820# sky130_fd_pr__nfet_01v8 ad=0.3 pd=1.6 as=0.6 ps=3.2 w=1 l=0.3
X236 counnew_0/a_2270_16920# counnew_0/a_1890_16920# counnew_0/w_n6450_16080# counnew_0/w_n6450_16080# sky130_fd_pr__pfet_01v8 ad=0.75 pd=3.1 as=1.5 ps=6.2 w=2.5 l=0.2
X237 counnew_0/a_6170_16920# counnew_0/a_5650_18860# counnew_0/w_n6450_16080# counnew_0/w_n6450_16080# sky130_fd_pr__pfet_01v8 ad=1.5 pd=6.2 as=1.5 ps=6.2 w=2.5 l=0.2
X238 counnew_0/a_n1310_12920# counnew_0/a_n1850_16920# counnew_0/a_n1490_12920# counnew_0/a_n6410_17820# sky130_fd_pr__nfet_01v8 ad=0.3 pd=1.6 as=0.3 ps=1.6 w=1 l=0.3
X239 counnew_0/a_90_12920# AND_0/out counnew_0/a_n90_12920# counnew_0/a_n6410_17820# sky130_fd_pr__nfet_01v8 ad=0.3 pd=1.6 as=0.3 ps=1.6 w=1 l=0.3
X240 counnew_0/w_n6450_16080# counnew_0/a_7170_16880# counnew_0/a_7050_16920# counnew_0/w_n6450_16080# sky130_fd_pr__pfet_01v8 ad=1.5 pd=6.2 as=0.75 ps=3.1 w=2.5 l=0.2
X241 counnew_0/a_2770_17820# counnew_0/a_1890_16920# counnew_0/a_2430_16920# counnew_0/a_n6410_17820# sky130_fd_pr__nfet_01v8 ad=0.3 pd=1.6 as=0.6 ps=3.2 w=1 l=0.2
X242 counnew_0/a_2230_17580# counnew_0/w_n6450_16080# counnew_0/w_n6450_16080# counnew_0/w_n6450_16080# sky130_fd_pr__pfet_01v8 ad=0.45 pd=2.1 as=0.9 ps=4.2 w=1.5 l=0.3
X243 counnew_0/a_6230_14580# counnew_0/a_6230_13340# counnew_0/w_n6450_16080# counnew_0/w_n6450_16080# sky130_fd_pr__pfet_01v8 ad=0.9 pd=4.2 as=0.45 ps=2.1 w=1.5 l=0.3
X244 counnew_0/a_8690_16920# counnew_0/a_8310_16920# counnew_0/w_n6450_16080# counnew_0/w_n6450_16080# sky130_fd_pr__pfet_01v8 ad=0.75 pd=3.1 as=1.5 ps=6.2 w=2.5 l=0.2
X245 counnew_0/a_n2050_14880# AND_0/out counnew_0/a_n2230_14880# counnew_0/a_n6410_17820# sky130_fd_pr__nfet_01v8 ad=0.3 pd=1.6 as=0.3 ps=1.6 w=1 l=0.3
X246 counnew_0/a_6510_17580# counnew_0/w_n6450_16080# counnew_0/w_n6450_16080# counnew_0/w_n6450_16080# sky130_fd_pr__pfet_01v8 ad=0.45 pd=2.1 as=0.9 ps=4.2 w=1.5 l=0.3
X247 counnew_0/a_7050_17820# counnew_0/a_6170_16920# counnew_0/a_6710_16920# counnew_0/a_n6410_17820# sky130_fd_pr__nfet_01v8 ad=0.3 pd=1.6 as=0.6 ps=3.2 w=1 l=0.2
X248 counnew_0/a_n6090_13480# counnew_0/a_n6190_13340# counnew_0/w_n6350_13440# counnew_0/w_n6350_13440# sky130_fd_pr__pfet_01v8 ad=0.45 pd=2.1 as=0.9 ps=4.2 w=1.5 l=0.3
X249 counnew_0/a_830_12920# counnew_0/a_290_16920# counnew_0/a_650_12920# counnew_0/a_n6410_17820# sky130_fd_pr__nfet_01v8 ad=0.3 pd=1.6 as=0.3 ps=1.6 w=1 l=0.3
X250 counnew_0/a_2130_15880# a_12560_n12690# counnew_0/a_2970_12920# counnew_0/a_n6410_17820# sky130_fd_pr__nfet_01v8 ad=0.6 pd=3.2 as=0.3 ps=1.6 w=1 l=0.3
X251 counnew_0/a_6710_16920# counnew_0/a_5650_18860# counnew_0/a_6550_17820# counnew_0/a_n6410_17820# sky130_fd_pr__nfet_01v8 ad=0.6 pd=3.2 as=0.3 ps=1.6 w=1 l=0.2
X252 counnew_0/a_4090_13340# a_12560_n12690# counnew_0/a_4370_14880# counnew_0/a_n6410_17820# sky130_fd_pr__nfet_01v8 ad=0.6 pd=3.2 as=0.3 ps=1.6 w=1 l=0.3
X253 counnew_0/w_n6350_13440# AND_0/out counnew_0/a_6330_13480# counnew_0/w_n6350_13440# sky130_fd_pr__pfet_01v8 ad=0.45 pd=2.1 as=0.45 ps=2.1 w=1.5 l=0.3
X254 counnew_0/a_7070_14220# a_12560_n12690# counnew_0/w_n6350_13440# counnew_0/w_n6350_13440# sky130_fd_pr__pfet_01v8 ad=0.9 pd=4.2 as=0.45 ps=2.1 w=1.5 l=0.3
X255 counnew_0/a_n2230_13480# counnew_0/a_n2330_13340# counnew_0/w_n6350_13440# counnew_0/w_n6350_13440# sky130_fd_pr__pfet_01v8 ad=0.45 pd=2.1 as=0.9 ps=4.2 w=1.5 l=0.3
X256 counnew_0/a_1370_18860# counnew_0/a_1050_18860# counnew_0/a_n6410_17820# counnew_0/a_n6410_17820# sky130_fd_pr__nfet_01v8 ad=0.42 pd=2.6 as=0.42 ps=2.6 w=0.7 l=0.2
X257 counnew_0/a_6510_17580# counnew_0/a_7070_14220# counnew_0/a_7250_15560# counnew_0/a_n6410_17820# sky130_fd_pr__nfet_01v8 ad=0.6 pd=3.2 as=0.3 ps=1.6 w=1 l=0.3
X258 counnew_0/a_n4190_17580# counnew_0/a_n3630_14220# counnew_0/w_n6450_16080# counnew_0/w_n6450_16080# sky130_fd_pr__pfet_01v8 ad=0.9 pd=4.2 as=0.45 ps=2.1 w=1.5 l=0.3
X259 counnew_0/w_n3430_18820# counnew_0/a_n2050_17580# counnew_0/a_n1090_18860# counnew_0/w_n3430_18820# sky130_fd_pr__pfet_01v8 ad=0.36 pd=1.8 as=0.36 ps=1.8 w=1.2 l=0.2
X260 counnew_0/a_5650_18860# counnew_0/a_5330_18860# counnew_0/w_n3430_18820# counnew_0/w_n3430_18820# sky130_fd_pr__pfet_01v8 ad=0.72 pd=3.6 as=0.36 ps=1.8 w=1.2 l=0.2
X261 counnew_0/a_n6090_13480# counnew_0/a_n6010_15880# counnew_0/a_n5910_12920# counnew_0/a_n6410_17820# sky130_fd_pr__nfet_01v8 ad=0.6 pd=3.2 as=0.3 ps=1.6 w=1 l=0.3
X262 counnew_0/a_n5350_14220# a_12560_n12690# counnew_0/a_n5170_14880# counnew_0/a_n6410_17820# sky130_fd_pr__nfet_01v8 ad=0.6 pd=3.2 as=0.3 ps=1.6 w=1 l=0.3
X263 counnew_0/a_7790_18860# counnew_0/a_7470_18860# counnew_0/a_n6410_17820# counnew_0/a_n6410_17820# sky130_fd_pr__nfet_01v8 ad=0.42 pd=2.6 as=0.42 ps=2.6 w=0.7 l=0.2
X264 counnew_0/a_n90_13480# counnew_0/a_n190_13340# counnew_0/w_n6350_13440# counnew_0/w_n6350_13440# sky130_fd_pr__pfet_01v8 ad=0.45 pd=2.1 as=0.9 ps=4.2 w=1.5 l=0.3
X265 counnew_0/a_n190_14580# counnew_0/a_n190_13340# counnew_0/w_n6450_16080# counnew_0/w_n6450_16080# sky130_fd_pr__pfet_01v8 ad=0.9 pd=4.2 as=0.45 ps=2.1 w=1.5 l=0.3
X266 counnew_0/w_n6350_13440# counnew_0/a_2050_13480# counnew_0/a_2790_14220# counnew_0/w_n6350_13440# sky130_fd_pr__pfet_01v8 ad=0.45 pd=2.1 as=0.45 ps=2.1 w=1.5 l=0.3
X267 counnew_0/a_4370_14880# AND_0/out counnew_0/a_4190_14880# counnew_0/a_n6410_17820# sky130_fd_pr__nfet_01v8 ad=0.3 pd=1.6 as=0.3 ps=1.6 w=1 l=0.3
X268 counnew_0/a_2970_15560# counnew_0/a_1950_13340# counnew_0/a_2790_15560# counnew_0/a_n6410_17820# sky130_fd_pr__nfet_01v8 ad=0.3 pd=1.6 as=0.3 ps=1.6 w=1 l=0.3
X269 counnew_0/a_n3230_18860# counnew_0/a_n4190_17580# counnew_0/a_n3230_18480# counnew_0/a_n6410_17820# sky130_fd_pr__nfet_01v8 ad=0.42 pd=2.6 as=0.21 ps=1.3 w=0.7 l=0.2
X270 counnew_0/a_9390_12920# counnew_0/a_8850_16920# counnew_0/a_9210_12920# counnew_0/a_n6410_17820# sky130_fd_pr__nfet_01v8 ad=0.3 pd=1.6 as=0.3 ps=1.6 w=1 l=0.3
X271 counnew_0/a_5330_18860# counnew_0/a_4370_17580# counnew_0/a_5330_18480# counnew_0/a_n6410_17820# sky130_fd_pr__nfet_01v8 ad=0.42 pd=2.6 as=0.21 ps=1.3 w=0.7 l=0.2
X272 counnew_0/w_n6350_13440# AND_0/out counnew_0/a_n2230_13480# counnew_0/w_n6350_13440# sky130_fd_pr__pfet_01v8 ad=0.45 pd=2.1 as=0.45 ps=2.1 w=1.5 l=0.3
X273 counnew_0/a_n3630_14220# counnew_0/a_n4190_17580# counnew_0/w_n6350_13440# counnew_0/w_n6350_13440# sky130_fd_pr__pfet_01v8 ad=0.45 pd=2.1 as=0.9 ps=4.2 w=1.5 l=0.3
X274 counnew_0/a_n1490_14220# a_12560_n12690# counnew_0/a_n1310_14880# counnew_0/a_n6410_17820# sky130_fd_pr__nfet_01v8 ad=0.6 pd=3.2 as=0.3 ps=1.6 w=1 l=0.3
X275 counnew_0/w_n6450_16080# counnew_0/a_4090_13340# counnew_0/a_4370_17580# counnew_0/w_n6450_16080# sky130_fd_pr__pfet_01v8 ad=0.45 pd=2.1 as=0.45 ps=2.1 w=1.5 l=0.3
X276 counnew_0/a_n3630_15560# counnew_0/w_n6450_16080# counnew_0/a_n6410_17820# counnew_0/a_n6410_17820# sky130_fd_pr__nfet_01v8 ad=0.3 pd=1.6 as=0.6 ps=3.2 w=1 l=0.3
X277 counnew_0/w_n6450_16080# counnew_0/a_6510_17580# counnew_0/a_7170_16880# counnew_0/w_n6450_16080# sky130_fd_pr__pfet_01v8 ad=1.5 pd=6.2 as=1.5 ps=6.2 w=2.5 l=0.2
X278 counnew_0/a_290_16920# counnew_0/a_n770_18860# counnew_0/a_130_17820# counnew_0/a_n6410_17820# sky130_fd_pr__nfet_01v8 ad=0.6 pd=3.2 as=0.3 ps=1.6 w=1 l=0.2
X279 counnew_0/a_n4470_13340# a_12560_n12690# counnew_0/w_n6350_13440# counnew_0/w_n6350_13440# sky130_fd_pr__pfet_01v8 ad=0.9 pd=4.2 as=0.45 ps=2.1 w=1.5 l=0.3
X280 counnew_0/a_n2910_18860# counnew_0/a_n3230_18860# counnew_0/a_n6410_17820# counnew_0/a_n6410_17820# sky130_fd_pr__nfet_01v8 ad=0.42 pd=2.6 as=0.42 ps=2.6 w=0.7 l=0.2
X281 counnew_0/a_n4470_14580# counnew_0/a_n4470_13340# counnew_0/a_n4190_15560# counnew_0/a_n6410_17820# sky130_fd_pr__nfet_01v8 ad=0.6 pd=3.2 as=0.3 ps=1.6 w=1 l=0.3
X282 counnew_0/w_n6450_16080# counnew_0/a_n6190_13340# counnew_0/a_n5910_17580# counnew_0/w_n6450_16080# sky130_fd_pr__pfet_01v8 ad=0.45 pd=2.1 as=0.45 ps=2.1 w=1.5 l=0.3
X283 counnew_0/w_n6450_16080# counnew_0/a_5030_16880# counnew_0/a_4910_16920# counnew_0/w_n6450_16080# sky130_fd_pr__pfet_01v8 ad=1.5 pd=6.2 as=0.75 ps=3.1 w=2.5 l=0.2
X284 counnew_0/a_n770_18860# counnew_0/a_n1090_18860# counnew_0/a_n6410_17820# counnew_0/a_n6410_17820# sky130_fd_pr__nfet_01v8 ad=0.42 pd=2.6 as=0.42 ps=2.6 w=0.7 l=0.2
X285 counnew_0/a_4190_13480# counnew_0/a_4270_15880# counnew_0/w_n6350_13440# counnew_0/w_n6350_13440# sky130_fd_pr__pfet_01v8 ad=0.9 pd=4.2 as=0.45 ps=2.1 w=1.5 l=0.3
X286 counnew_0/a_650_14880# counnew_0/a_90_17580# counnew_0/a_n6410_17820# counnew_0/a_n6410_17820# sky130_fd_pr__nfet_01v8 ad=0.3 pd=1.6 as=0.6 ps=3.2 w=1 l=0.3
X287 counnew_0/a_6550_16920# counnew_0/a_6170_16920# counnew_0/w_n6450_16080# counnew_0/w_n6450_16080# sky130_fd_pr__pfet_01v8 ad=0.75 pd=3.1 as=1.5 ps=6.2 w=2.5 l=0.2
X288 counnew_0/w_n6350_13440# counnew_0/a_n4370_13480# counnew_0/a_n3630_14220# counnew_0/w_n6350_13440# sky130_fd_pr__pfet_01v8 ad=0.45 pd=2.1 as=0.45 ps=2.1 w=1.5 l=0.3
X289 counnew_0/a_n3450_15560# counnew_0/a_n4470_13340# counnew_0/a_n3630_15560# counnew_0/a_n6410_17820# sky130_fd_pr__nfet_01v8 ad=0.3 pd=1.6 as=0.3 ps=1.6 w=1 l=0.3
X290 counnew_0/w_n6450_16080# counnew_0/a_n10_15880# counnew_0/a_n190_14580# counnew_0/w_n6450_16080# sky130_fd_pr__pfet_01v8 ad=0.45 pd=2.1 as=0.45 ps=2.1 w=1.5 l=0.3
X291 counnew_0/w_n6450_16080# counnew_0/a_n2330_13340# counnew_0/a_n2050_17580# counnew_0/w_n6450_16080# sky130_fd_pr__pfet_01v8 ad=0.45 pd=2.1 as=0.45 ps=2.1 w=1.5 l=0.3
X292 counnew_0/a_n6010_15880# a_12560_n12690# counnew_0/w_n6350_13440# counnew_0/w_n6350_13440# sky130_fd_pr__pfet_01v8 ad=0.9 pd=4.2 as=0.45 ps=2.1 w=1.5 l=0.3
X293 counnew_0/a_4570_16920# counnew_0/a_3510_18860# counnew_0/a_4410_17820# counnew_0/a_n6410_17820# sky130_fd_pr__nfet_01v8 ad=0.6 pd=3.2 as=0.3 ps=1.6 w=1 l=0.2
X294 counnew_0/w_n3430_18820# counnew_0/a_90_17580# counnew_0/a_1050_18860# counnew_0/w_n3430_18820# sky130_fd_pr__pfet_01v8 ad=0.36 pd=1.8 as=0.36 ps=1.8 w=1.2 l=0.2
X295 counnew_0/w_n6450_16080# counnew_0/a_n5250_16880# counnew_0/a_n5370_16920# counnew_0/w_n6450_16080# sky130_fd_pr__pfet_01v8 ad=1.5 pd=6.2 as=0.75 ps=3.1 w=2.5 l=0.2
X296 counnew_0/a_1950_13340# a_12560_n12690# counnew_0/a_2230_14880# counnew_0/a_n6410_17820# sky130_fd_pr__nfet_01v8 ad=0.6 pd=3.2 as=0.3 ps=1.6 w=1 l=0.3
X297 counnew_0/w_n6350_13440# AND_0/out counnew_0/a_4190_13480# counnew_0/w_n6350_13440# sky130_fd_pr__pfet_01v8 ad=0.45 pd=2.1 as=0.45 ps=2.1 w=1.5 l=0.3
X298 counnew_0/a_1950_13340# counnew_0/a_1950_14580# counnew_0/w_n6350_13440# counnew_0/w_n6350_13440# sky130_fd_pr__pfet_01v8 ad=0.45 pd=2.1 as=0.9 ps=4.2 w=1.5 l=0.3
X299 counnew_0/a_n6250_16920# counnew_0/w_n6450_16080# counnew_0/w_n6450_16080# counnew_0/w_n6450_16080# sky130_fd_pr__pfet_01v8 ad=1.5 pd=6.2 as=1.5 ps=6.2 w=2.5 l=0.2
X300 counnew_0/a_6410_15880# a_12560_n12690# counnew_0/a_7250_12920# counnew_0/a_n6410_17820# sky130_fd_pr__nfet_01v8 ad=0.6 pd=3.2 as=0.3 ps=1.6 w=1 l=0.3
X301 counnew_0/w_n6450_16080# counnew_0/a_n190_13340# counnew_0/a_90_17580# counnew_0/w_n6450_16080# sky130_fd_pr__pfet_01v8 ad=0.45 pd=2.1 as=0.45 ps=2.1 w=1.5 l=0.3
X302 counnew_0/a_4930_14220# a_12560_n12690# counnew_0/w_n6350_13440# counnew_0/w_n6350_13440# sky130_fd_pr__pfet_01v8 ad=0.9 pd=4.2 as=0.45 ps=2.1 w=1.5 l=0.3
X303 counnew_0/a_2050_15560# counnew_0/w_n6450_16080# counnew_0/a_n6410_17820# counnew_0/a_n6410_17820# sky130_fd_pr__nfet_01v8 ad=0.3 pd=1.6 as=0.6 ps=3.2 w=1 l=0.3
X304 counnew_0/a_n5710_16920# counnew_0/w_n6450_16080# counnew_0/a_n5870_17820# counnew_0/a_n6410_17820# sky130_fd_pr__nfet_01v8 ad=0.6 pd=3.2 as=0.3 ps=1.6 w=1 l=0.2
X305 counnew_0/w_n3430_18820# counnew_0/a_6510_17580# counnew_0/a_7470_18860# counnew_0/w_n3430_18820# sky130_fd_pr__pfet_01v8 ad=0.36 pd=1.8 as=0.36 ps=1.8 w=1.2 l=0.2
X306 counnew_0/a_6230_13340# counnew_0/a_6230_14580# counnew_0/w_n6350_13440# counnew_0/w_n6350_13440# sky130_fd_pr__pfet_01v8 ad=0.45 pd=2.1 as=0.9 ps=4.2 w=1.5 l=0.3
X307 counnew_0/a_4930_14880# counnew_0/a_4370_17580# counnew_0/a_n6410_17820# counnew_0/a_n6410_17820# sky130_fd_pr__nfet_01v8 ad=0.3 pd=1.6 as=0.6 ps=3.2 w=1 l=0.3
X308 counnew_0/a_4370_17580# counnew_0/a_4930_14220# counnew_0/a_5110_15560# counnew_0/a_n6410_17820# sky130_fd_pr__nfet_01v8 ad=0.6 pd=3.2 as=0.3 ps=1.6 w=1 l=0.3
X309 counnew_0/a_2230_17580# counnew_0/a_2790_14220# counnew_0/w_n6450_16080# counnew_0/w_n6450_16080# sky130_fd_pr__pfet_01v8 ad=0.9 pd=4.2 as=0.45 ps=2.1 w=1.5 l=0.3
X310 counnew_0/a_n2150_15880# a_12560_n12690# counnew_0/w_n6350_13440# counnew_0/w_n6350_13440# sky130_fd_pr__pfet_01v8 ad=0.9 pd=4.2 as=0.45 ps=2.1 w=1.5 l=0.3
X311 counnew_0/a_8370_13340# a_12560_n12690# counnew_0/a_8650_14880# counnew_0/a_n6410_17820# sky130_fd_pr__nfet_01v8 ad=0.6 pd=3.2 as=0.3 ps=1.6 w=1 l=0.3
X312 counnew_0/a_n5350_14220# counnew_0/a_n5910_17580# counnew_0/w_n6350_13440# counnew_0/w_n6350_13440# sky130_fd_pr__pfet_01v8 ad=0.45 pd=2.1 as=0.9 ps=4.2 w=1.5 l=0.3
X313 counnew_0/a_6330_15560# counnew_0/w_n6450_16080# counnew_0/a_n6410_17820# counnew_0/a_n6410_17820# sky130_fd_pr__nfet_01v8 ad=0.3 pd=1.6 as=0.6 ps=3.2 w=1 l=0.3
X314 counnew_0/w_n6450_16080# counnew_0/a_750_16880# counnew_0/a_630_16920# counnew_0/w_n6450_16080# sky130_fd_pr__pfet_01v8 ad=1.5 pd=6.2 as=0.75 ps=3.1 w=2.5 l=0.2
X315 counnew_0/a_9210_14880# counnew_0/a_8650_17580# counnew_0/a_n6410_17820# counnew_0/a_n6410_17820# sky130_fd_pr__nfet_01v8 ad=0.3 pd=1.6 as=0.6 ps=3.2 w=1 l=0.3
X316 counnew_0/a_n5350_15560# counnew_0/w_n6450_16080# counnew_0/a_n6410_17820# counnew_0/a_n6410_17820# sky130_fd_pr__nfet_01v8 ad=0.3 pd=1.6 as=0.6 ps=3.2 w=1 l=0.3
X317 counnew_0/w_n6450_16080# counnew_0/a_n1390_16880# counnew_0/a_n1510_16920# counnew_0/w_n6450_16080# sky130_fd_pr__pfet_01v8 ad=1.5 pd=6.2 as=0.75 ps=3.1 w=2.5 l=0.2
X318 counnew_0/a_2970_12920# counnew_0/a_2430_16920# counnew_0/a_2790_12920# counnew_0/a_n6410_17820# sky130_fd_pr__nfet_01v8 ad=0.3 pd=1.6 as=0.3 ps=1.6 w=1 l=0.3
X319 counnew_0/a_n1850_16920# counnew_0/a_n2910_18860# counnew_0/a_n2010_17820# counnew_0/a_n6410_17820# sky130_fd_pr__nfet_01v8 ad=0.6 pd=3.2 as=0.3 ps=1.6 w=1 l=0.2
X320 counnew_0/a_n6190_14580# counnew_0/a_n6190_13340# counnew_0/w_n6450_16080# counnew_0/w_n6450_16080# sky130_fd_pr__pfet_01v8 ad=0.9 pd=4.2 as=0.45 ps=2.1 w=1.5 l=0.3
X321 counnew_0/a_3190_18860# counnew_0/a_2230_17580# counnew_0/a_3190_18480# counnew_0/a_n6410_17820# sky130_fd_pr__nfet_01v8 ad=0.42 pd=2.6 as=0.21 ps=1.3 w=0.7 l=0.2
X322 counnew_0/a_n10_15880# counnew_0/a_n90_13480# counnew_0/w_n6350_13440# counnew_0/w_n6350_13440# sky130_fd_pr__pfet_01v8 ad=0.45 pd=2.1 as=0.9 ps=4.2 w=1.5 l=0.3
X323 counnew_0/a_n3630_12920# counnew_0/a_n4370_13480# counnew_0/a_n6410_17820# counnew_0/a_n6410_17820# sky130_fd_pr__nfet_01v8 ad=0.3 pd=1.6 as=0.6 ps=3.2 w=1 l=0.3
X324 counnew_0/a_n1490_14220# counnew_0/a_n2050_17580# counnew_0/w_n6350_13440# counnew_0/w_n6350_13440# sky130_fd_pr__pfet_01v8 ad=0.45 pd=2.1 as=0.9 ps=4.2 w=1.5 l=0.3
X325 counnew_0/a_n250_16920# counnew_0/a_n770_18860# counnew_0/w_n6450_16080# counnew_0/w_n6450_16080# sky130_fd_pr__pfet_01v8 ad=1.5 pd=6.2 as=1.5 ps=6.2 w=2.5 l=0.2
X326 counnew_0/a_n1490_15560# counnew_0/w_n6450_16080# counnew_0/a_n6410_17820# counnew_0/a_n6410_17820# sky130_fd_pr__nfet_01v8 ad=0.3 pd=1.6 as=0.6 ps=3.2 w=1 l=0.3
X327 counnew_0/a_n4370_13480# counnew_0/a_n4290_15880# counnew_0/a_n4190_12920# counnew_0/a_n6410_17820# sky130_fd_pr__nfet_01v8 ad=0.6 pd=3.2 as=0.3 ps=1.6 w=1 l=0.3
X328 counnew_0/a_130_16920# counnew_0/a_n250_16920# counnew_0/w_n6450_16080# counnew_0/w_n6450_16080# sky130_fd_pr__pfet_01v8 ad=0.75 pd=3.1 as=1.5 ps=6.2 w=2.5 l=0.2
X329 counnew_0/a_n4370_14880# counnew_0/a_n4470_14580# counnew_0/a_n6410_17820# counnew_0/a_n6410_17820# sky130_fd_pr__nfet_01v8 ad=0.3 pd=1.6 as=0.6 ps=3.2 w=1 l=0.3
X330 counnew_0/a_n6410_17820# counnew_0/a_90_17580# counnew_0/a_750_16880# counnew_0/a_n6410_17820# sky130_fd_pr__nfet_01v8 ad=0.6 pd=3.2 as=0.6 ps=3.2 w=1 l=0.2
X331 counnew_0/w_n6450_16080# counnew_0/a_8370_13340# counnew_0/a_8650_17580# counnew_0/w_n6450_16080# sky130_fd_pr__pfet_01v8 ad=0.45 pd=2.1 as=0.45 ps=2.1 w=1.5 l=0.3
X332 counnew_0/a_650_14220# a_12560_n12690# counnew_0/w_n6350_13440# counnew_0/w_n6350_13440# sky130_fd_pr__pfet_01v8 ad=0.9 pd=4.2 as=0.45 ps=2.1 w=1.5 l=0.3
X333 counnew_0/a_2050_13480# counnew_0/a_2130_15880# counnew_0/w_n6350_13440# counnew_0/w_n6350_13440# sky130_fd_pr__pfet_01v8 ad=0.9 pd=4.2 as=0.45 ps=2.1 w=1.5 l=0.3
X334 counnew_0/a_n3450_12920# counnew_0/a_n3990_16920# counnew_0/a_n3630_12920# counnew_0/a_n6410_17820# sky130_fd_pr__nfet_01v8 ad=0.3 pd=1.6 as=0.3 ps=1.6 w=1 l=0.3
X335 counnew_0/a_90_17580# counnew_0/a_650_14220# counnew_0/a_830_15560# counnew_0/a_n6410_17820# sky130_fd_pr__nfet_01v8 ad=0.6 pd=3.2 as=0.3 ps=1.6 w=1 l=0.3
X336 counnew_0/w_n6450_16080# counnew_0/a_9310_16880# counnew_0/a_9190_16920# counnew_0/w_n6450_16080# sky130_fd_pr__pfet_01v8 ad=1.5 pd=6.2 as=0.75 ps=3.1 w=2.5 l=0.2
X337 counnew_0/a_4270_15880# counnew_0/a_4190_13480# counnew_0/w_n6350_13440# counnew_0/w_n6350_13440# sky130_fd_pr__pfet_01v8 ad=0.45 pd=2.1 as=0.9 ps=4.2 w=1.5 l=0.3
X338 counnew_0/a_8470_13480# counnew_0/a_8550_15880# counnew_0/w_n6350_13440# counnew_0/w_n6350_13440# sky130_fd_pr__pfet_01v8 ad=0.9 pd=4.2 as=0.45 ps=2.1 w=1.5 l=0.3
X339 counnew_0/a_7250_14880# counnew_0/a_6330_13480# counnew_0/a_7070_14880# counnew_0/a_n6410_17820# sky130_fd_pr__nfet_01v8 ad=0.3 pd=1.6 as=0.3 ps=1.6 w=1 l=0.3
X340 counnew_0/a_8550_15880# counnew_0/a_8470_13480# counnew_0/w_n6350_13440# counnew_0/w_n6350_13440# sky130_fd_pr__pfet_01v8 ad=0.45 pd=2.1 as=0.9 ps=4.2 w=1.5 l=0.3
X341 counnew_0/a_2050_12920# counnew_0/a_1950_13340# counnew_0/a_n6410_17820# counnew_0/a_n6410_17820# sky130_fd_pr__nfet_01v8 ad=0.3 pd=1.6 as=0.6 ps=3.2 w=1 l=0.3
X342 counnew_0/w_n6350_13440# AND_0/out counnew_0/a_n6190_13340# counnew_0/w_n6350_13440# sky130_fd_pr__pfet_01v8 ad=0.45 pd=2.1 as=0.45 ps=2.1 w=1.5 l=0.3
X343 counnew_0/a_n5910_15560# counnew_0/a_n6010_15880# counnew_0/a_n6090_15560# counnew_0/a_n6410_17820# sky130_fd_pr__nfet_01v8 ad=0.3 pd=1.6 as=0.3 ps=1.6 w=1 l=0.3
X344 counnew_0/a_4270_15880# a_12560_n12690# counnew_0/a_5110_12920# counnew_0/a_n6410_17820# sky130_fd_pr__nfet_01v8 ad=0.6 pd=3.2 as=0.3 ps=1.6 w=1 l=0.3
X345 counnew_0/w_n3430_18820# counnew_0/a_n4190_17580# counnew_0/a_n3230_18860# counnew_0/w_n3430_18820# sky130_fd_pr__pfet_01v8 ad=0.36 pd=1.8 as=0.36 ps=1.8 w=1.2 l=0.2
X346 counnew_0/a_8850_16920# counnew_0/a_7790_18860# counnew_0/a_8690_17820# counnew_0/a_n6410_17820# sky130_fd_pr__nfet_01v8 ad=0.6 pd=3.2 as=0.3 ps=1.6 w=1 l=0.2
X347 counnew_0/w_n3430_18820# counnew_0/a_4370_17580# counnew_0/a_5330_18860# counnew_0/w_n3430_18820# sky130_fd_pr__pfet_01v8 ad=0.36 pd=1.8 as=0.36 ps=1.8 w=1.2 l=0.2
X348 counnew_0/a_6330_12920# counnew_0/a_6230_13340# counnew_0/a_n6410_17820# counnew_0/a_n6410_17820# sky130_fd_pr__nfet_01v8 ad=0.3 pd=1.6 as=0.6 ps=3.2 w=1 l=0.3
X349 counnew_0/a_4090_13340# counnew_0/a_4090_14580# counnew_0/w_n6350_13440# counnew_0/w_n6350_13440# sky130_fd_pr__pfet_01v8 ad=0.45 pd=2.1 as=0.9 ps=4.2 w=1.5 l=0.3
X350 counnew_0/a_2790_14880# counnew_0/a_2230_17580# counnew_0/a_n6410_17820# counnew_0/a_n6410_17820# sky130_fd_pr__nfet_01v8 ad=0.3 pd=1.6 as=0.6 ps=3.2 w=1 l=0.3
X351 counnew_0/a_6230_13340# a_12560_n12690# counnew_0/a_6510_14880# counnew_0/a_n6410_17820# sky130_fd_pr__nfet_01v8 ad=0.6 pd=3.2 as=0.3 ps=1.6 w=1 l=0.3
X352 counnew_0/a_n5350_12920# counnew_0/a_n6090_13480# counnew_0/a_n6410_17820# counnew_0/a_n6410_17820# sky130_fd_pr__nfet_01v8 ad=0.3 pd=1.6 as=0.6 ps=3.2 w=1 l=0.3
X353 counnew_0/a_4190_15560# counnew_0/w_n6450_16080# counnew_0/a_n6410_17820# counnew_0/a_n6410_17820# sky130_fd_pr__nfet_01v8 ad=0.3 pd=1.6 as=0.6 ps=3.2 w=1 l=0.3
X354 counnew_0/a_9210_14220# a_12560_n12690# counnew_0/w_n6350_13440# counnew_0/w_n6350_13440# sky130_fd_pr__pfet_01v8 ad=0.9 pd=4.2 as=0.45 ps=2.1 w=1.5 l=0.3
X355 counnew_0/a_n4370_13480# counnew_0/a_n4470_13340# counnew_0/w_n6350_13440# counnew_0/w_n6350_13440# sky130_fd_pr__pfet_01v8 ad=0.45 pd=2.1 as=0.9 ps=4.2 w=1.5 l=0.3
X356 counnew_0/a_7070_14880# counnew_0/a_6510_17580# counnew_0/a_n6410_17820# counnew_0/a_n6410_17820# sky130_fd_pr__nfet_01v8 ad=0.3 pd=1.6 as=0.6 ps=3.2 w=1 l=0.3
X357 counnew_0/a_8650_17580# counnew_0/a_9210_14220# counnew_0/a_9390_15560# counnew_0/a_n6410_17820# sky130_fd_pr__nfet_01v8 ad=0.6 pd=3.2 as=0.3 ps=1.6 w=1 l=0.3
X358 counnew_0/a_6510_17580# counnew_0/a_7070_14220# counnew_0/w_n6450_16080# counnew_0/w_n6450_16080# sky130_fd_pr__pfet_01v8 ad=0.9 pd=4.2 as=0.45 ps=2.1 w=1.5 l=0.3
X359 counnew_0/a_n4150_16920# counnew_0/a_n4530_16920# counnew_0/w_n6450_16080# counnew_0/w_n6450_16080# sky130_fd_pr__pfet_01v8 ad=0.75 pd=3.1 as=1.5 ps=6.2 w=2.5 l=0.2
X360 counnew_0/a_5330_18480# counnew_0/a_3510_18860# counnew_0/a_n6410_17820# counnew_0/a_n6410_17820# sky130_fd_pr__nfet_01v8 ad=0.21 pd=1.3 as=0.42 ps=2.6 w=0.7 l=0.2
X361 counnew_0/a_n1490_12920# counnew_0/a_n2230_13480# counnew_0/a_n6410_17820# counnew_0/a_n6410_17820# sky130_fd_pr__nfet_01v8 ad=0.3 pd=1.6 as=0.6 ps=3.2 w=1 l=0.3
X362 counnew_0/a_n3990_16920# counnew_0/a_n5910_17580# counnew_0/a_n4150_17820# counnew_0/a_n6410_17820# sky130_fd_pr__nfet_01v8 ad=0.6 pd=3.2 as=0.3 ps=1.6 w=1 l=0.2
X363 counnew_0/w_n6450_16080# counnew_0/a_1950_13340# counnew_0/a_2230_17580# counnew_0/w_n6450_16080# sky130_fd_pr__pfet_01v8 ad=0.45 pd=2.1 as=0.45 ps=2.1 w=1.5 l=0.3
X364 counnew_0/w_n6450_16080# counnew_0/a_n4190_17580# counnew_0/a_n3530_16880# counnew_0/w_n6450_16080# sky130_fd_pr__pfet_01v8 ad=1.5 pd=6.2 as=1.5 ps=6.2 w=2.5 l=0.2
X365 counnew_0/a_n2330_13340# a_12560_n12690# counnew_0/w_n6350_13440# counnew_0/w_n6350_13440# sky130_fd_pr__pfet_01v8 ad=0.9 pd=4.2 as=0.45 ps=2.1 w=1.5 l=0.3
X366 counnew_0/a_n3630_14220# a_12560_n12690# counnew_0/a_n3450_14880# counnew_0/a_n6410_17820# sky130_fd_pr__nfet_01v8 ad=0.6 pd=3.2 as=0.3 ps=1.6 w=1 l=0.3
X367 counnew_0/w_n6350_13440# counnew_0/a_6710_16920# counnew_0/a_6410_15880# counnew_0/w_n6350_13440# sky130_fd_pr__pfet_01v8 ad=0.45 pd=2.1 as=0.45 ps=2.1 w=1.5 l=0.3
X368 counnew_0/a_n2330_14580# counnew_0/a_n2330_13340# counnew_0/a_n2050_15560# counnew_0/a_n6410_17820# sky130_fd_pr__nfet_01v8 ad=0.6 pd=3.2 as=0.3 ps=1.6 w=1 l=0.3
X369 counnew_0/a_n3650_17820# counnew_0/a_n4530_16920# counnew_0/a_n3990_16920# counnew_0/a_n6410_17820# sky130_fd_pr__nfet_01v8 ad=0.3 pd=1.6 as=0.6 ps=3.2 w=1 l=0.2
X370 counnew_0/a_n4190_17580# counnew_0/w_n6450_16080# counnew_0/w_n6450_16080# counnew_0/w_n6450_16080# sky130_fd_pr__pfet_01v8 ad=0.45 pd=2.1 as=0.9 ps=4.2 w=1.5 l=0.3
X371 counnew_0/a_n10_15880# a_12560_n12690# counnew_0/a_830_12920# counnew_0/a_n6410_17820# sky130_fd_pr__nfet_01v8 ad=0.6 pd=3.2 as=0.3 ps=1.6 w=1 l=0.3
X372 counnew_0/a_n6410_17820# counnew_0/a_4370_17580# counnew_0/a_5030_16880# counnew_0/a_n6410_17820# sky130_fd_pr__nfet_01v8 ad=0.6 pd=3.2 as=0.6 ps=3.2 w=1 l=0.2
X373 counnew_0/a_n190_13340# a_12560_n12690# counnew_0/a_90_14880# counnew_0/a_n6410_17820# sky130_fd_pr__nfet_01v8 ad=0.6 pd=3.2 as=0.3 ps=1.6 w=1 l=0.3
X374 counnew_0/a_n4470_14580# counnew_0/a_n4470_13340# counnew_0/w_n6450_16080# counnew_0/w_n6450_16080# sky130_fd_pr__pfet_01v8 ad=0.9 pd=4.2 as=0.45 ps=2.1 w=1.5 l=0.3
X375 counnew_0/w_n6350_13440# AND_0/out counnew_0/a_1950_13340# counnew_0/w_n6350_13440# sky130_fd_pr__pfet_01v8 ad=0.45 pd=2.1 as=0.45 ps=2.1 w=1.5 l=0.3
X376 counnew_0/a_4030_16920# counnew_0/a_3510_18860# counnew_0/a_n6410_17820# counnew_0/a_n6410_17820# sky130_fd_pr__nfet_01v8 ad=0.6 pd=3.2 as=0.6 ps=3.2 w=1 l=0.2
X377 counnew_0/a_2130_15880# counnew_0/a_2050_13480# counnew_0/w_n6350_13440# counnew_0/w_n6350_13440# sky130_fd_pr__pfet_01v8 ad=0.45 pd=2.1 as=0.9 ps=4.2 w=1.5 l=0.3
X378 counnew_0/a_6330_13480# counnew_0/a_6410_15880# counnew_0/w_n6350_13440# counnew_0/w_n6350_13440# sky130_fd_pr__pfet_01v8 ad=0.9 pd=4.2 as=0.45 ps=2.1 w=1.5 l=0.3
X379 counnew_0/a_2230_15560# counnew_0/a_2130_15880# counnew_0/a_2050_15560# counnew_0/a_n6410_17820# sky130_fd_pr__nfet_01v8 ad=0.3 pd=1.6 as=0.3 ps=1.6 w=1 l=0.3
X380 counnew_0/a_4410_17820# counnew_0/a_4370_17580# counnew_0/a_n6410_17820# counnew_0/a_n6410_17820# sky130_fd_pr__nfet_01v8 ad=0.3 pd=1.6 as=0.6 ps=3.2 w=1 l=0.2
X381 counnew_0/a_5110_14880# counnew_0/a_4190_13480# counnew_0/a_4930_14880# counnew_0/a_n6410_17820# sky130_fd_pr__nfet_01v8 ad=0.3 pd=1.6 as=0.3 ps=1.6 w=1 l=0.3
X382 counnew_0/a_8310_16920# counnew_0/a_7790_18860# counnew_0/a_n6410_17820# counnew_0/a_n6410_17820# sky130_fd_pr__nfet_01v8 ad=0.6 pd=3.2 as=0.6 ps=3.2 w=1 l=0.2
X383 counnew_0/a_6410_15880# counnew_0/a_6330_13480# counnew_0/w_n6350_13440# counnew_0/w_n6350_13440# sky130_fd_pr__pfet_01v8 ad=0.45 pd=2.1 as=0.9 ps=4.2 w=1.5 l=0.3
X384 counnew_0/w_n6350_13440# AND_0/out counnew_0/a_8370_13340# counnew_0/w_n6350_13440# sky130_fd_pr__pfet_01v8 ad=0.45 pd=2.1 as=0.45 ps=2.1 w=1.5 l=0.3
X385 counnew_0/w_n6450_16080# counnew_0/a_n4470_13340# counnew_0/a_n4190_17580# counnew_0/w_n6450_16080# sky130_fd_pr__pfet_01v8 ad=0.45 pd=2.1 as=0.45 ps=2.1 w=1.5 l=0.3
X386 counnew_0/a_n5910_12920# AND_0/out counnew_0/a_n6090_12920# counnew_0/a_n6410_17820# sky130_fd_pr__nfet_01v8 ad=0.3 pd=1.6 as=0.3 ps=1.6 w=1 l=0.3
X387 counnew_0/a_8650_15560# counnew_0/a_8550_15880# counnew_0/a_8470_15560# counnew_0/a_n6410_17820# sky130_fd_pr__nfet_01v8 ad=0.3 pd=1.6 as=0.3 ps=1.6 w=1 l=0.3
X388 counnew_0/a_n5170_14880# counnew_0/a_n6090_13480# counnew_0/a_n5350_14880# counnew_0/a_n6410_17820# sky130_fd_pr__nfet_01v8 ad=0.3 pd=1.6 as=0.3 ps=1.6 w=1 l=0.3
X389 counnew_0/w_n3430_18820# counnew_0/a_2230_17580# counnew_0/a_3190_18860# counnew_0/w_n3430_18820# sky130_fd_pr__pfet_01v8 ad=0.36 pd=1.8 as=0.36 ps=1.8 w=1.2 l=0.2
X390 counnew_0/a_4190_12920# counnew_0/a_4090_13340# counnew_0/a_n6410_17820# counnew_0/a_n6410_17820# sky130_fd_pr__nfet_01v8 ad=0.3 pd=1.6 as=0.6 ps=3.2 w=1 l=0.3
X391 counnew_0/a_630_16920# counnew_0/a_n770_18860# counnew_0/a_290_16920# counnew_0/w_n6450_16080# sky130_fd_pr__pfet_01v8 ad=0.75 pd=3.1 as=1.5 ps=6.2 w=2.5 l=0.2
X392 counnew_0/a_8550_15880# a_12560_n12690# counnew_0/a_9390_12920# counnew_0/a_n6410_17820# sky130_fd_pr__nfet_01v8 ad=0.6 pd=3.2 as=0.3 ps=1.6 w=1 l=0.3
X393 counnew_0/a_1950_14580# counnew_0/w_n6450_16080# counnew_0/w_n6450_16080# counnew_0/w_n6450_16080# sky130_fd_pr__pfet_01v8 ad=0.45 pd=2.1 as=0.9 ps=4.2 w=1.5 l=0.3
X394 counnew_0/a_8370_13340# counnew_0/a_8370_14580# counnew_0/w_n6350_13440# counnew_0/w_n6350_13440# sky130_fd_pr__pfet_01v8 ad=0.45 pd=2.1 as=0.9 ps=4.2 w=1.5 l=0.3
X395 counnew_0/a_n1310_14880# counnew_0/a_n2230_13480# counnew_0/a_n1490_14880# counnew_0/a_n6410_17820# sky130_fd_pr__nfet_01v8 ad=0.3 pd=1.6 as=0.3 ps=1.6 w=1 l=0.3
X396 counnew_0/a_4370_17580# counnew_0/a_4930_14220# counnew_0/w_n6450_16080# counnew_0/w_n6450_16080# sky130_fd_pr__pfet_01v8 ad=0.9 pd=4.2 as=0.45 ps=2.1 w=1.5 l=0.3
X397 counnew_0/a_n4290_15880# a_12560_n12690# counnew_0/w_n6350_13440# counnew_0/w_n6350_13440# sky130_fd_pr__pfet_01v8 ad=0.9 pd=4.2 as=0.45 ps=2.1 w=1.5 l=0.3
X398 counnew_0/a_90_14880# AND_0/out counnew_0/a_n90_14880# counnew_0/a_n6410_17820# sky130_fd_pr__nfet_01v8 ad=0.3 pd=1.6 as=0.3 ps=1.6 w=1 l=0.3
X399 counnew_0/a_n2010_16920# counnew_0/a_n2390_16920# counnew_0/w_n6450_16080# counnew_0/w_n6450_16080# sky130_fd_pr__pfet_01v8 ad=0.75 pd=3.1 as=1.5 ps=6.2 w=2.5 l=0.2
X400 counnew_0/a_3190_18480# counnew_0/a_1370_18860# counnew_0/a_n6410_17820# counnew_0/a_n6410_17820# sky130_fd_pr__nfet_01v8 ad=0.21 pd=1.3 as=0.42 ps=2.6 w=0.7 l=0.2
X401 counnew_0/a_8470_15560# counnew_0/w_n6450_16080# counnew_0/a_n6410_17820# counnew_0/a_n6410_17820# sky130_fd_pr__nfet_01v8 ad=0.3 pd=1.6 as=0.6 ps=3.2 w=1 l=0.3
X402 counnew_0/a_6230_14580# counnew_0/w_n6450_16080# counnew_0/w_n6450_16080# counnew_0/w_n6450_16080# sky130_fd_pr__pfet_01v8 ad=0.45 pd=2.1 as=0.9 ps=4.2 w=1.5 l=0.3
X403 counnew_0/w_n6350_13440# AND_0/out counnew_0/a_n4470_13340# counnew_0/w_n6350_13440# sky130_fd_pr__pfet_01v8 ad=0.45 pd=2.1 as=0.45 ps=2.1 w=1.5 l=0.3
X404 counnew_0/w_n6450_16080# counnew_0/a_n3530_16880# counnew_0/a_n3650_16920# counnew_0/w_n6450_16080# sky130_fd_pr__pfet_01v8 ad=1.5 pd=6.2 as=0.75 ps=3.1 w=2.5 l=0.2
X405 counnew_0/a_n5370_17820# counnew_0/a_n6250_16920# counnew_0/a_n5710_16920# counnew_0/a_n6410_17820# sky130_fd_pr__nfet_01v8 ad=0.3 pd=1.6 as=0.6 ps=3.2 w=1 l=0.2
X406 counnew_0/a_n4190_15560# counnew_0/a_n4290_15880# counnew_0/a_n4370_15560# counnew_0/a_n6410_17820# sky130_fd_pr__nfet_01v8 ad=0.3 pd=1.6 as=0.3 ps=1.6 w=1 l=0.3
X407 counnew_0/a_n5910_17580# counnew_0/w_n6450_16080# counnew_0/w_n6450_16080# counnew_0/w_n6450_16080# sky130_fd_pr__pfet_01v8 ad=0.45 pd=2.1 as=0.9 ps=4.2 w=1.5 l=0.3
X408 counnew_0/a_n90_13480# counnew_0/a_n10_15880# counnew_0/w_n6350_13440# counnew_0/w_n6350_13440# sky130_fd_pr__pfet_01v8 ad=0.9 pd=4.2 as=0.45 ps=2.1 w=1.5 l=0.3
X409 counnew_0/a_n4530_16920# counnew_0/a_n5910_17580# counnew_0/w_n6450_16080# counnew_0/w_n6450_16080# sky130_fd_pr__pfet_01v8 ad=1.5 pd=6.2 as=1.5 ps=6.2 w=2.5 l=0.2
X410 counnew_0/w_n6450_16080# counnew_0/a_n2050_17580# counnew_0/a_n1390_16880# counnew_0/w_n6450_16080# sky130_fd_pr__pfet_01v8 ad=1.5 pd=6.2 as=1.5 ps=6.2 w=2.5 l=0.2
X411 counnew_0/a_830_14880# counnew_0/a_n90_13480# counnew_0/a_650_14880# counnew_0/a_n6410_17820# sky130_fd_pr__nfet_01v8 ad=0.3 pd=1.6 as=0.3 ps=1.6 w=1 l=0.3
X412 counnew_0/a_n2230_13480# counnew_0/a_n2150_15880# counnew_0/a_n2050_12920# counnew_0/a_n6410_17820# sky130_fd_pr__nfet_01v8 ad=0.6 pd=3.2 as=0.3 ps=1.6 w=1 l=0.3
X413 counnew_0/a_2790_14220# a_12560_n12690# counnew_0/a_2970_14880# counnew_0/a_n6410_17820# sky130_fd_pr__nfet_01v8 ad=0.6 pd=3.2 as=0.3 ps=1.6 w=1 l=0.3
X414 counnew_0/w_n6350_13440# counnew_0/a_4570_16920# counnew_0/a_4270_15880# counnew_0/w_n6350_13440# sky130_fd_pr__pfet_01v8 ad=0.45 pd=2.1 as=0.45 ps=2.1 w=1.5 l=0.3
X415 counnew_0/a_4910_16920# counnew_0/a_3510_18860# counnew_0/a_4570_16920# counnew_0/w_n6450_16080# sky130_fd_pr__pfet_01v8 ad=0.75 pd=3.1 as=1.5 ps=6.2 w=2.5 l=0.2
X416 counnew_0/a_n1510_17820# counnew_0/a_n2390_16920# counnew_0/a_n1850_16920# counnew_0/a_n6410_17820# sky130_fd_pr__nfet_01v8 ad=0.3 pd=1.6 as=0.6 ps=3.2 w=1 l=0.2
X417 counnew_0/a_n2050_17580# counnew_0/w_n6450_16080# counnew_0/w_n6450_16080# counnew_0/w_n6450_16080# sky130_fd_pr__pfet_01v8 ad=0.45 pd=2.1 as=0.9 ps=4.2 w=1.5 l=0.3
X418 counnew_0/a_n6410_17820# counnew_0/a_2230_17580# counnew_0/a_2890_16880# counnew_0/a_n6410_17820# sky130_fd_pr__nfet_01v8 ad=0.6 pd=3.2 as=0.6 ps=3.2 w=1 l=0.2
X419 counnew_0/a_9190_16920# counnew_0/a_7790_18860# counnew_0/a_8850_16920# counnew_0/w_n6450_16080# sky130_fd_pr__pfet_01v8 ad=0.75 pd=3.1 as=1.5 ps=6.2 w=2.5 l=0.2
X420 counnew_0/w_n6350_13440# counnew_0/a_n5710_16920# counnew_0/a_n6010_15880# counnew_0/w_n6350_13440# sky130_fd_pr__pfet_01v8 ad=0.45 pd=2.1 as=0.45 ps=2.1 w=1.5 l=0.3
X421 counnew_0/a_2430_16920# counnew_0/a_2230_17580# counnew_0/a_2270_16920# counnew_0/w_n6450_16080# sky130_fd_pr__pfet_01v8 ad=1.5 pd=6.2 as=0.75 ps=3.1 w=2.5 l=0.2
X422 counnew_0/a_2230_12920# AND_0/out counnew_0/a_2050_12920# counnew_0/a_n6410_17820# sky130_fd_pr__nfet_01v8 ad=0.3 pd=1.6 as=0.3 ps=1.6 w=1 l=0.3
X423 counnew_0/a_n6190_13340# counnew_0/a_n6190_14580# counnew_0/w_n6350_13440# counnew_0/w_n6350_13440# sky130_fd_pr__pfet_01v8 ad=0.45 pd=2.1 as=0.9 ps=4.2 w=1.5 l=0.3
X424 counnew_0/a_1890_16920# counnew_0/a_1370_18860# counnew_0/a_n6410_17820# counnew_0/a_n6410_17820# sky130_fd_pr__nfet_01v8 ad=0.6 pd=3.2 as=0.6 ps=3.2 w=1 l=0.2
X425 counnew_0/a_n6090_15560# counnew_0/w_n6450_16080# counnew_0/a_n6410_17820# counnew_0/a_n6410_17820# sky130_fd_pr__nfet_01v8 ad=0.3 pd=1.6 as=0.6 ps=3.2 w=1 l=0.3
X426 counnew_0/a_n6190_13340# a_12560_n12690# counnew_0/a_n5910_14880# counnew_0/a_n6410_17820# sky130_fd_pr__nfet_01v8 ad=0.6 pd=3.2 as=0.3 ps=1.6 w=1 l=0.3
X427 counnew_0/a_n6410_17820# counnew_0/a_8650_17580# counnew_0/a_9310_16880# counnew_0/a_n6410_17820# sky130_fd_pr__nfet_01v8 ad=0.6 pd=3.2 as=0.6 ps=3.2 w=1 l=0.2
X428 counnew_0/a_n6410_17820# counnew_0/a_2890_16880# counnew_0/a_2770_17820# counnew_0/a_n6410_17820# sky130_fd_pr__nfet_01v8 ad=0.6 pd=3.2 as=0.3 ps=1.6 w=1 l=0.2
X429 counnew_0/a_90_17580# counnew_0/a_650_14220# counnew_0/w_n6450_16080# counnew_0/w_n6450_16080# sky130_fd_pr__pfet_01v8 ad=0.9 pd=4.2 as=0.45 ps=2.1 w=1.5 l=0.3
X430 counnew_0/a_2270_17820# counnew_0/a_2230_17580# counnew_0/a_n6410_17820# counnew_0/a_n6410_17820# sky130_fd_pr__nfet_01v8 ad=0.3 pd=1.6 as=0.6 ps=3.2 w=1 l=0.2
X431 counnew_0/a_6170_16920# counnew_0/a_5650_18860# counnew_0/a_n6410_17820# counnew_0/a_n6410_17820# sky130_fd_pr__nfet_01v8 ad=0.6 pd=3.2 as=0.6 ps=3.2 w=1 l=0.2
X432 counnew_0/a_8650_12920# AND_0/out counnew_0/a_8470_12920# counnew_0/a_n6410_17820# sky130_fd_pr__nfet_01v8 ad=0.3 pd=1.6 as=0.3 ps=1.6 w=1 l=0.3
X433 counnew_0/w_n6350_13440# AND_0/out counnew_0/a_6230_13340# counnew_0/w_n6350_13440# sky130_fd_pr__pfet_01v8 ad=0.45 pd=2.1 as=0.45 ps=2.1 w=1.5 l=0.3
X434 counnew_0/a_n6410_17820# counnew_0/a_7170_16880# counnew_0/a_7050_17820# counnew_0/a_n6410_17820# sky130_fd_pr__nfet_01v8 ad=0.6 pd=3.2 as=0.3 ps=1.6 w=1 l=0.2
X435 counnew_0/w_n6350_13440# counnew_0/a_n1850_16920# counnew_0/a_n2150_15880# counnew_0/w_n6350_13440# sky130_fd_pr__pfet_01v8 ad=0.45 pd=2.1 as=0.45 ps=2.1 w=1.5 l=0.3
X436 counnew_0/w_n6350_13440# AND_0/out counnew_0/a_n90_13480# counnew_0/w_n6350_13440# sky130_fd_pr__pfet_01v8 ad=0.45 pd=2.1 as=0.45 ps=2.1 w=1.5 l=0.3
X437 counnew_0/a_6510_15560# counnew_0/a_6410_15880# counnew_0/a_6330_15560# counnew_0/a_n6410_17820# sky130_fd_pr__nfet_01v8 ad=0.3 pd=1.6 as=0.3 ps=1.6 w=1 l=0.3
X438 counnew_0/a_n2330_13340# counnew_0/a_n2330_14580# counnew_0/w_n6350_13440# counnew_0/w_n6350_13440# sky130_fd_pr__pfet_01v8 ad=0.45 pd=2.1 as=0.9 ps=4.2 w=1.5 l=0.3
X439 counnew_0/a_8690_17820# counnew_0/a_8650_17580# counnew_0/a_n6410_17820# counnew_0/a_n6410_17820# sky130_fd_pr__nfet_01v8 ad=0.3 pd=1.6 as=0.6 ps=3.2 w=1 l=0.2
X440 counnew_0/a_5330_18860# counnew_0/a_3510_18860# counnew_0/w_n3430_18820# counnew_0/w_n3430_18820# sky130_fd_pr__pfet_01v8 ad=0.36 pd=1.8 as=0.72 ps=3.6 w=1.2 l=0.2
X441 counnew_0/a_9390_14880# counnew_0/a_8470_13480# counnew_0/a_9210_14880# counnew_0/a_n6410_17820# sky130_fd_pr__nfet_01v8 ad=0.3 pd=1.6 as=0.3 ps=1.6 w=1 l=0.3
X442 counnew_0/a_n2230_15560# counnew_0/w_n6450_16080# counnew_0/a_n6410_17820# counnew_0/a_n6410_17820# sky130_fd_pr__nfet_01v8 ad=0.3 pd=1.6 as=0.6 ps=3.2 w=1 l=0.3
X443 counnew_0/a_n5870_16920# counnew_0/a_n6250_16920# counnew_0/w_n6450_16080# counnew_0/w_n6450_16080# sky130_fd_pr__pfet_01v8 ad=0.75 pd=3.1 as=1.5 ps=6.2 w=2.5 l=0.2
X444 counnew_0/a_n190_13340# counnew_0/a_n190_14580# counnew_0/w_n6350_13440# counnew_0/w_n6350_13440# sky130_fd_pr__pfet_01v8 ad=0.45 pd=2.1 as=0.9 ps=4.2 w=1.5 l=0.3
X445 counnew_0/w_n6450_16080# counnew_0/a_n6010_15880# counnew_0/a_n6190_14580# counnew_0/w_n6450_16080# sky130_fd_pr__pfet_01v8 ad=0.45 pd=2.1 as=0.45 ps=2.1 w=1.5 l=0.3
X446 counnew_0/w_n6350_13440# counnew_0/a_290_16920# counnew_0/a_n10_15880# counnew_0/w_n6350_13440# sky130_fd_pr__pfet_01v8 ad=0.45 pd=2.1 as=0.45 ps=2.1 w=1.5 l=0.3
X447 counnew_0/a_n90_15560# counnew_0/w_n6450_16080# counnew_0/a_n6410_17820# counnew_0/a_n6410_17820# sky130_fd_pr__nfet_01v8 ad=0.3 pd=1.6 as=0.6 ps=3.2 w=1 l=0.3
X448 counnew_0/a_8470_12920# counnew_0/a_8370_13340# counnew_0/a_n6410_17820# counnew_0/a_n6410_17820# sky130_fd_pr__nfet_01v8 ad=0.3 pd=1.6 as=0.6 ps=3.2 w=1 l=0.3
X449 counnew_0/a_2130_15880# a_12560_n12690# counnew_0/w_n6350_13440# counnew_0/w_n6350_13440# sky130_fd_pr__pfet_01v8 ad=0.9 pd=4.2 as=0.45 ps=2.1 w=1.5 l=0.3
X450 counnew_0/w_n6450_16080# counnew_0/a_n5910_17580# counnew_0/a_n5250_16880# counnew_0/w_n6450_16080# sky130_fd_pr__pfet_01v8 ad=1.5 pd=6.2 as=1.5 ps=6.2 w=2.5 l=0.2
X451 counnew_0/a_n4190_12920# AND_0/out counnew_0/a_n4370_12920# counnew_0/a_n6410_17820# sky130_fd_pr__nfet_01v8 ad=0.3 pd=1.6 as=0.3 ps=1.6 w=1 l=0.3
X452 counnew_0/a_4090_14580# counnew_0/w_n6450_16080# counnew_0/w_n6450_16080# counnew_0/w_n6450_16080# sky130_fd_pr__pfet_01v8 ad=0.45 pd=2.1 as=0.9 ps=4.2 w=1.5 l=0.3
X453 counnew_0/a_1050_18480# counnew_0/a_n770_18860# counnew_0/a_n6410_17820# counnew_0/a_n6410_17820# sky130_fd_pr__nfet_01v8 ad=0.21 pd=1.3 as=0.42 ps=2.6 w=0.7 l=0.2
X454 counnew_0/w_n6350_13440# AND_0/out counnew_0/a_n2330_13340# counnew_0/w_n6350_13440# sky130_fd_pr__pfet_01v8 ad=0.45 pd=2.1 as=0.45 ps=2.1 w=1.5 l=0.3
X455 counnew_0/a_n2050_15560# counnew_0/a_n2150_15880# counnew_0/a_n2230_15560# counnew_0/a_n6410_17820# sky130_fd_pr__nfet_01v8 ad=0.3 pd=1.6 as=0.3 ps=1.6 w=1 l=0.3
X456 counnew_0/a_8650_17580# counnew_0/a_9210_14220# counnew_0/w_n6450_16080# counnew_0/w_n6450_16080# sky130_fd_pr__pfet_01v8 ad=0.9 pd=4.2 as=0.45 ps=2.1 w=1.5 l=0.3
X457 counnew_0/a_n2390_16920# counnew_0/a_n2910_18860# counnew_0/w_n6450_16080# counnew_0/w_n6450_16080# sky130_fd_pr__pfet_01v8 ad=1.5 pd=6.2 as=1.5 ps=6.2 w=2.5 l=0.2
X458 counnew_0/a_7470_18480# counnew_0/a_5650_18860# counnew_0/a_n6410_17820# counnew_0/a_n6410_17820# sky130_fd_pr__nfet_01v8 ad=0.21 pd=1.3 as=0.42 ps=2.6 w=0.7 l=0.2
X459 counnew_0/a_n3230_18480# counnew_0/a_n5910_17580# counnew_0/a_n6410_17820# counnew_0/a_n6410_17820# sky130_fd_pr__nfet_01v8 ad=0.21 pd=1.3 as=0.42 ps=2.6 w=0.7 l=0.2
X460 counnew_0/a_n6090_13480# counnew_0/a_n6010_15880# counnew_0/w_n6350_13440# counnew_0/w_n6350_13440# sky130_fd_pr__pfet_01v8 ad=0.9 pd=4.2 as=0.45 ps=2.1 w=1.5 l=0.3
X461 counnew_0/a_2770_16920# counnew_0/a_1370_18860# counnew_0/a_2430_16920# counnew_0/w_n6450_16080# sky130_fd_pr__pfet_01v8 ad=0.75 pd=3.1 as=1.5 ps=6.2 w=2.5 l=0.2
X462 counnew_0/a_4090_13340# a_12560_n12690# counnew_0/w_n6350_13440# counnew_0/w_n6350_13440# sky130_fd_pr__pfet_01v8 ad=0.9 pd=4.2 as=0.45 ps=2.1 w=1.5 l=0.3
X463 counnew_0/a_4090_14580# counnew_0/a_4090_13340# counnew_0/a_4370_15560# counnew_0/a_n6410_17820# sky130_fd_pr__nfet_01v8 ad=0.6 pd=3.2 as=0.3 ps=1.6 w=1 l=0.3
X464 counnew_0/a_7050_16920# counnew_0/a_5650_18860# counnew_0/a_6710_16920# counnew_0/w_n6450_16080# sky130_fd_pr__pfet_01v8 ad=0.75 pd=3.1 as=1.5 ps=6.2 w=2.5 l=0.2
X465 counnew_0/a_n6090_12920# counnew_0/a_n6190_13340# counnew_0/a_n6410_17820# counnew_0/a_n6410_17820# sky130_fd_pr__nfet_01v8 ad=0.3 pd=1.6 as=0.6 ps=3.2 w=1 l=0.3
X466 counnew_0/a_7070_14220# a_12560_n12690# counnew_0/a_7250_14880# counnew_0/a_n6410_17820# sky130_fd_pr__nfet_01v8 ad=0.6 pd=3.2 as=0.3 ps=1.6 w=1 l=0.3
X467 counnew_0/w_n6350_13440# counnew_0/a_8850_16920# counnew_0/a_8550_15880# counnew_0/w_n6350_13440# sky130_fd_pr__pfet_01v8 ad=0.45 pd=2.1 as=0.45 ps=2.1 w=1.5 l=0.3
X468 counnew_0/a_n2330_14580# counnew_0/a_n2330_13340# counnew_0/w_n6450_16080# counnew_0/w_n6450_16080# sky130_fd_pr__pfet_01v8 ad=0.9 pd=4.2 as=0.45 ps=2.1 w=1.5 l=0.3
X469 counnew_0/a_n5350_14220# a_12560_n12690# counnew_0/w_n6350_13440# counnew_0/w_n6350_13440# sky130_fd_pr__pfet_01v8 ad=0.9 pd=4.2 as=0.45 ps=2.1 w=1.5 l=0.3
X470 counnew_0/a_n6410_17820# counnew_0/a_6510_17580# counnew_0/a_7170_16880# counnew_0/a_n6410_17820# sky130_fd_pr__nfet_01v8 ad=0.6 pd=3.2 as=0.6 ps=3.2 w=1 l=0.2
X471 counnew_0/a_n5910_17580# counnew_0/a_n5350_14220# counnew_0/a_n5170_15560# counnew_0/a_n6410_17820# sky130_fd_pr__nfet_01v8 ad=0.6 pd=3.2 as=0.3 ps=1.6 w=1 l=0.3
X472 counnew_0/a_6710_16920# counnew_0/a_6510_17580# counnew_0/a_6550_16920# counnew_0/w_n6450_16080# sky130_fd_pr__pfet_01v8 ad=1.5 pd=6.2 as=0.75 ps=3.1 w=2.5 l=0.2
X473 counnew_0/a_6510_12920# AND_0/out counnew_0/a_6330_12920# counnew_0/a_n6410_17820# sky130_fd_pr__nfet_01v8 ad=0.3 pd=1.6 as=0.3 ps=1.6 w=1 l=0.3
X474 counnew_0/w_n6350_13440# AND_0/out counnew_0/a_4090_13340# counnew_0/w_n6350_13440# sky130_fd_pr__pfet_01v8 ad=0.45 pd=2.1 as=0.45 ps=2.1 w=1.5 l=0.3
X475 counnew_0/a_2970_14880# counnew_0/a_2050_13480# counnew_0/a_2790_14880# counnew_0/a_n6410_17820# sky130_fd_pr__nfet_01v8 ad=0.3 pd=1.6 as=0.3 ps=1.6 w=1 l=0.3
X476 counnew_0/a_n6410_17820# counnew_0/a_5030_16880# counnew_0/a_4910_17820# counnew_0/a_n6410_17820# sky130_fd_pr__nfet_01v8 ad=0.6 pd=3.2 as=0.3 ps=1.6 w=1 l=0.2
X477 counnew_0/a_n2230_12920# counnew_0/a_n2330_13340# counnew_0/a_n6410_17820# counnew_0/a_n6410_17820# sky130_fd_pr__nfet_01v8 ad=0.3 pd=1.6 as=0.6 ps=3.2 w=1 l=0.3
X478 counnew_0/a_4370_15560# counnew_0/a_4270_15880# counnew_0/a_4190_15560# counnew_0/a_n6410_17820# sky130_fd_pr__nfet_01v8 ad=0.3 pd=1.6 as=0.3 ps=1.6 w=1 l=0.3
X479 counnew_0/w_n6450_16080# counnew_0/a_2130_15880# counnew_0/a_1950_14580# counnew_0/w_n6450_16080# sky130_fd_pr__pfet_01v8 ad=0.45 pd=2.1 as=0.45 ps=2.1 w=1.5 l=0.3
X480 counnew_0/a_6550_17820# counnew_0/a_6510_17580# counnew_0/a_n6410_17820# counnew_0/a_n6410_17820# sky130_fd_pr__nfet_01v8 ad=0.3 pd=1.6 as=0.6 ps=3.2 w=1 l=0.2
X481 counnew_0/a_3190_18860# counnew_0/a_1370_18860# counnew_0/w_n3430_18820# counnew_0/w_n3430_18820# sky130_fd_pr__pfet_01v8 ad=0.36 pd=1.8 as=0.72 ps=3.6 w=1.2 l=0.2
X482 counnew_0/a_n1490_14220# a_12560_n12690# counnew_0/w_n6350_13440# counnew_0/w_n6350_13440# sky130_fd_pr__pfet_01v8 ad=0.9 pd=4.2 as=0.45 ps=2.1 w=1.5 l=0.3
X483 counnew_0/a_n2910_18860# counnew_0/a_n3230_18860# counnew_0/w_n3430_18820# counnew_0/w_n3430_18820# sky130_fd_pr__pfet_01v8 ad=0.72 pd=3.6 as=0.36 ps=1.8 w=1.2 l=0.2
X484 counnew_0/a_n3630_14880# counnew_0/a_n4190_17580# counnew_0/a_n6410_17820# counnew_0/a_n6410_17820# sky130_fd_pr__nfet_01v8 ad=0.3 pd=1.6 as=0.6 ps=3.2 w=1 l=0.3
X485 counnew_0/a_n2050_17580# counnew_0/a_n1490_14220# counnew_0/a_n1310_15560# counnew_0/a_n6410_17820# sky130_fd_pr__nfet_01v8 ad=0.6 pd=3.2 as=0.3 ps=1.6 w=1 l=0.3
X486 counnew_0/a_n90_12920# counnew_0/a_n190_13340# counnew_0/a_n6410_17820# counnew_0/a_n6410_17820# sky130_fd_pr__nfet_01v8 ad=0.3 pd=1.6 as=0.6 ps=3.2 w=1 l=0.3
X487 counnew_0/w_n6450_16080# counnew_0/a_8550_15880# counnew_0/a_8370_14580# counnew_0/w_n6450_16080# sky130_fd_pr__pfet_01v8 ad=0.45 pd=2.1 as=0.45 ps=2.1 w=1.5 l=0.3
X488 counnew_0/a_n4470_13340# a_12560_n12690# counnew_0/a_n4190_14880# counnew_0/a_n6410_17820# sky130_fd_pr__nfet_01v8 ad=0.6 pd=3.2 as=0.3 ps=1.6 w=1 l=0.3
X489 counnew_0/a_n770_18860# counnew_0/a_n1090_18860# counnew_0/w_n3430_18820# counnew_0/w_n3430_18820# sky130_fd_pr__pfet_01v8 ad=0.72 pd=3.6 as=0.36 ps=1.8 w=1.2 l=0.2
X490 counnew_0/a_n2050_12920# AND_0/out counnew_0/a_n2230_12920# counnew_0/a_n6410_17820# sky130_fd_pr__nfet_01v8 ad=0.3 pd=1.6 as=0.3 ps=1.6 w=1 l=0.3
X491 counnew_0/a_650_14220# counnew_0/a_90_17580# counnew_0/w_n6350_13440# counnew_0/w_n6350_13440# sky130_fd_pr__pfet_01v8 ad=0.45 pd=2.1 as=0.9 ps=4.2 w=1.5 l=0.3
X492 counnew_0/a_n6410_17820# counnew_0/a_n5250_16880# counnew_0/a_n5370_17820# counnew_0/a_n6410_17820# sky130_fd_pr__nfet_01v8 ad=0.6 pd=3.2 as=0.3 ps=1.6 w=1 l=0.2
X493 counnew_0/a_650_15560# counnew_0/w_n6450_16080# counnew_0/a_n6410_17820# counnew_0/a_n6410_17820# sky130_fd_pr__nfet_01v8 ad=0.3 pd=1.6 as=0.6 ps=3.2 w=1 l=0.3
X494 counnew_0/a_n6250_16920# counnew_0/w_n6450_16080# counnew_0/a_n6410_17820# counnew_0/a_n6410_17820# sky130_fd_pr__nfet_01v8 ad=0.6 pd=3.2 as=0.6 ps=3.2 w=1 l=0.2
X495 counnew_0/a_n3450_14880# counnew_0/a_n4370_13480# counnew_0/a_n3630_14880# counnew_0/a_n6410_17820# sky130_fd_pr__nfet_01v8 ad=0.3 pd=1.6 as=0.3 ps=1.6 w=1 l=0.3
X496 counnew_0/a_6410_15880# a_12560_n12690# counnew_0/w_n6350_13440# counnew_0/w_n6350_13440# sky130_fd_pr__pfet_01v8 ad=0.9 pd=4.2 as=0.45 ps=2.1 w=1.5 l=0.3
X497 AND_0/Vdd sw1cs_0/a_n660_5160# sw1cs_0/a_n780_5200# AND_0/Vdd sky130_fd_pr__pfet_01v8 ad=0.6 pd=3.2 as=0.6 ps=3.2 w=1 l=1
X498 a_8160_n13210# li_7710_n8950# sw1cs_0/a_n780_5200# AND_0/Vdd sky130_fd_pr__pfet_01v8 ad=0.3 pd=2.2 as=0.3 ps=2.2 w=0.5 l=0.2
X499 m2_4740_n7410# m1_7540_n9240# sw1cs_0/a_n660_5160# gnd sky130_fd_pr__nfet_01v8 ad=2.4 pd=9.2 as=2.4 ps=9.2 w=4 l=0.2
X500 AND_0/Vdd m1_7540_n9240# sw1cs_0/a_n660_5160# AND_0/Vdd sky130_fd_pr__pfet_01v8 ad=1.2 pd=5.2 as=1.2 ps=5.2 w=2 l=0.2
X501 AND_0/Vdd m1_7540_n9240# li_7710_n8950# AND_0/Vdd sky130_fd_pr__pfet_01v8 ad=3 pd=11.2 as=1.5 ps=5.6 w=5 l=0.2
X502 m2_3470_n16750# m1_7540_n14840# li_7680_n13980# m2_3470_n16750# sky130_fd_pr__pfet_01v8 ad=3 pd=11.2 as=1.5 ps=5.6 w=5 l=0.2
X503 li_7690_n11680# sw_0/a_n540_n2470# AND_0/Vdd AND_0/Vdd sky130_fd_pr__pfet_01v8 ad=1.5 pd=5.6 as=3 ps=11.2 w=5 l=0.2
X504 sw_0/a_n540_120# li_5730_n12230# gnd gnd sky130_fd_pr__nfet_01v8 ad=2.34 pd=9 as=2.34 ps=9 w=3.9 l=0.2
X505 sw_0/a_n540_120# li_5730_n12230# AND_0/Vdd AND_0/Vdd sky130_fd_pr__pfet_01v8 ad=3 pd=11.2 as=3 ps=11.2 w=5 l=0.2
X506 sw_0/a_n180_n2470# sw_0/a_n540_n2470# gnd gnd sky130_fd_pr__nfet_01v8 ad=1.17 pd=4.5 as=2.34 ps=9 w=3.9 l=0.2
X507 sw_0/a_n540_n5000# li_5730_n12230# gnd gnd sky130_fd_pr__nfet_01v8 ad=2.34 pd=9 as=2.34 ps=9 w=3.9 l=0.2
X508 sw_0/a_n540_n2470# li_5730_n12230# AND_0/Vdd AND_0/Vdd sky130_fd_pr__pfet_01v8 ad=3 pd=11.2 as=3 ps=11.2 w=5 l=0.2
X509 li_7680_n13980# m1_7540_n14840# sw_0/a_n180_n3690# gnd sky130_fd_pr__nfet_01v8 ad=2.34 pd=9 as=1.17 ps=4.5 w=3.9 l=0.2
X510 sw_0/a_n540_n2470# li_5730_n12230# gnd gnd sky130_fd_pr__nfet_01v8 ad=2.34 pd=9 as=2.34 ps=9 w=3.9 l=0.2
X511 li_7680_n13980# sw_0/a_n540_n5000# m2_3470_n16750# m2_3470_n16750# sky130_fd_pr__pfet_01v8 ad=1.5 pd=5.6 as=3 ps=11.2 w=5 l=0.2
X512 li_7710_n8950# sw_0/a_n540_120# AND_0/Vdd AND_0/Vdd sky130_fd_pr__pfet_01v8 ad=1.5 pd=5.6 as=3 ps=11.2 w=5 l=0.2
X513 AND_0/Vdd m1_7540_n11780# li_7690_n11680# AND_0/Vdd sky130_fd_pr__pfet_01v8 ad=3 pd=11.2 as=1.5 ps=5.6 w=5 l=0.2
X514 sw_0/a_n180_1450# sw_0/a_n540_120# gnd gnd sky130_fd_pr__nfet_01v8 ad=1.17 pd=4.5 as=2.34 ps=9 w=3.9 l=0.2
X515 li_7710_n8950# m1_7540_n9240# sw_0/a_n180_1450# gnd sky130_fd_pr__nfet_01v8 ad=2.34 pd=9 as=1.17 ps=4.5 w=3.9 l=0.2
X516 li_7690_n11680# m1_7540_n11780# sw_0/a_n180_n2470# gnd sky130_fd_pr__nfet_01v8 ad=2.34 pd=9 as=1.17 ps=4.5 w=3.9 l=0.2
X517 sw_0/a_n540_n5000# li_5730_n12230# m2_3470_n16750# m2_3470_n16750# sky130_fd_pr__pfet_01v8 ad=3 pd=11.2 as=3 ps=11.2 w=5 l=0.2
X518 sw_0/a_n180_n3690# sw_0/a_n540_n5000# gnd gnd sky130_fd_pr__nfet_01v8 ad=1.17 pd=4.5 as=2.34 ps=9 w=3.9 l=0.2
X519 a_1120_n13160# AND_0/b AND_0/a gnd sky130_fd_pr__nfet_01v8 ad=6 pd=21.2 as=6 ps=21.2 w=10 l=0.2
X520 a_1120_n13160# a_1030_n8160# AND_0/a AND_0/Vdd sky130_fd_pr__pfet_01v8 ad=7.2 pd=25.2 as=7.2 ps=25.2 w=12 l=0.2
X521 a_8160_n13210# a_8120_n13290# gnd gnd sky130_fd_pr__nfet_01v8 ad=2.4 pd=9.2 as=2.4 ps=9.2 w=4 l=0.2
X522 AND_0/Vdd a_12560_n12690# a_8120_n13290# AND_0/Vdd sky130_fd_pr__pfet_01v8 ad=3 pd=11.2 as=3 ps=11.2 w=5 l=0.2
X523 gnd a_12560_n12690# a_8120_n13290# gnd sky130_fd_pr__nfet_01v8 ad=1.5 pd=6.2 as=1.5 ps=6.2 w=2.5 l=0.2
X524 gnd AND_0/b a_1030_n8160# gnd sky130_fd_pr__nfet_01v8 ad=1.5 pd=6.2 as=1.5 ps=6.2 w=2.5 l=0.2
X525 AND_0/Vdd AND_0/b a_1030_n8160# AND_0/Vdd sky130_fd_pr__pfet_01v8 ad=3 pd=11.2 as=3 ps=11.2 w=5 l=0.2
C0 a_12560_n12690# counnew_0/w_n6350_13440# 7.65544f
C1 li_5730_n12230# AND_0/Vdd 2.07205f
C2 a_8160_n13210# AND_0/Vdd 2.82076f
C3 counnew_0/a_n5910_17580# counnew_0/w_n6450_16080# 2.33637f
C4 counnew_0/w_n6450_16080# counnew_0/a_n4190_17580# 2.05748f
C5 counnew_0/w_n6450_16080# counnew_0/a_4370_17580# 2.06453f
C6 counnew_0/w_n6450_16080# counnew_0/a_6510_17580# 2.06453f
C7 counnew_0/w_n6450_16080# counnew_0/a_90_17580# 2.06453f
C8 counnew_0/w_n6450_16080# counnew_0/a_2230_17580# 2.06453f
C9 AND_0/out counnew_0/w_n6350_13440# 5.26099f
C10 AND_0/b AND_0/Vdd 2.25893f
C11 counnew_0/w_n6450_16080# counnew_0/a_n2050_17580# 2.06453f
C12 a_8120_n13290# counnew_0/a_n6410_17820# 3.55786f **FLOATING
C13 AND_0/Vdd counnew_0/a_n6410_17820# 69.13503f **FLOATING
C14 li_5730_n12230# counnew_0/a_n6410_17820# 4.48324f **FLOATING
C15 a_12560_n12690# counnew_0/a_n6410_17820# 27.53339f **FLOATING
C16 counnew_0/a_n6190_13340# counnew_0/a_n6410_17820# 2.17746f **FLOATING
C17 counnew_0/a_n6010_15880# counnew_0/a_n6410_17820# 2.30473f **FLOATING
C18 counnew_0/a_8650_17580# counnew_0/a_n6410_17820# 2.47686f **FLOATING
C19 counnew_0/a_n5710_16920# counnew_0/a_n6410_17820# 2.01982f **FLOATING
C20 counnew_0/a_6510_17580# counnew_0/a_n6410_17820# 2.90439f **FLOATING
C21 counnew_0/a_5650_18860# counnew_0/a_n6410_17820# 2.56166f **FLOATING
C22 counnew_0/a_4370_17580# counnew_0/a_n6410_17820# 2.90408f **FLOATING
C23 counnew_0/a_3510_18860# counnew_0/a_n6410_17820# 2.56166f **FLOATING
C24 counnew_0/a_2230_17580# counnew_0/a_n6410_17820# 2.90408f **FLOATING
C25 counnew_0/a_1370_18860# counnew_0/a_n6410_17820# 2.56166f **FLOATING
C26 counnew_0/a_90_17580# counnew_0/a_n6410_17820# 2.90408f **FLOATING
C27 counnew_0/a_n770_18860# counnew_0/a_n6410_17820# 2.56166f **FLOATING
C28 counnew_0/a_n2050_17580# counnew_0/a_n6410_17820# 2.90408f **FLOATING
C29 counnew_0/a_n2910_18860# counnew_0/a_n6410_17820# 2.56166f **FLOATING
C30 counnew_0/a_n4190_17580# counnew_0/a_n6410_17820# 2.94397f **FLOATING
C31 counnew_0/a_n5910_17580# counnew_0/a_n6410_17820# 4.47561f **FLOATING
C32 counnew_0/w_n6350_13440# counnew_0/a_n6410_17820# 56.2379f **FLOATING
C33 counnew_0/w_n6450_16080# counnew_0/a_n6410_17820# 75.66f **FLOATING
C34 counnew_0/w_n3430_18820# counnew_0/a_n6410_17820# 22.377f **FLOATING
C35 m2_1930_n14060# counnew_0/a_n6410_17820# 4.0251f **FLOATING
C36 AND_0/b counnew_0/a_n6410_17820# 14.08309f
C37 m2_3470_n16750# counnew_0/a_n6410_17820# 41.0585f **FLOATING
C38 a_1120_n13160# counnew_0/a_n6410_17820# 2.78137f **FLOATING
C39 compnew_0/a_n122_5000# counnew_0/a_n6410_17820# 2.66712f **FLOATING
C40 m2_4740_n7410# counnew_0/a_n6410_17820# 7.77494f **FLOATING
C41 a_8160_n13210# counnew_0/a_n6410_17820# 5.93484f **FLOATING
C42 AND_0/out counnew_0/a_n6410_17820# 19.06048f
C43 AND_0/a counnew_0/a_n6410_17820# 4.3047f
C44 a_1030_n8160# counnew_0/a_n6410_17820# 3.11629f **FLOATING
C45 csvc_0/a_6158_200# counnew_0/a_n6410_17820# 2.80039f **FLOATING
C46 csvc_0/a_5628_n60# counnew_0/a_n6410_17820# 4.01093f **FLOATING
