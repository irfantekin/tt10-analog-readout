* SPICE3 file created from tt_um_irfantekin_analog.ext - technology: sky130A

X0 VGND uio_in[4] newdene_0/m2_4740_n7410# VGND sky130_fd_pr__nfet_01v8 ad=0.6 pd=3.2 as=0.6 ps=3.2 w=1 l=13.5
X1 VGND uio_in[1] newdene_0/m2_4740_n7410# VGND sky130_fd_pr__nfet_01v8 ad=0.6 pd=3.2 as=0.6 ps=3.2 w=1 l=3.5
X2 VGND uio_in[0] newdene_0/m2_4740_n7410# VGND sky130_fd_pr__nfet_01v8 ad=0.6 pd=3.2 as=0.6 ps=3.2 w=1 l=2
X3 VGND uio_in[2] newdene_0/m2_4740_n7410# VGND sky130_fd_pr__nfet_01v8 ad=0.6 pd=3.2 as=0.6 ps=3.2 w=1 l=6.5
X4 newdene_0/m2_4740_n7410# newdene_0/m2_4740_n7410# newdene_0/csvc_0/a_6788_n630# VDPWR sky130_fd_pr__pfet_01v8 ad=3 pd=11.2 as=3 ps=11.2 w=5 l=3
X5 newdene_0/csvc_0/a_6788_n630# newdene_0/a_1030_n8160# VDPWR VDPWR sky130_fd_pr__pfet_01v8 ad=3 pd=11.2 as=3 ps=11.2 w=5 l=0.2
X6 VGND uio_in[3] newdene_0/m2_4740_n7410# VGND sky130_fd_pr__nfet_01v8 ad=0.6 pd=3.2 as=0.6 ps=3.2 w=1 l=10
X7 newdene_0/AND_0/a_n2700_2180# clk VDPWR VDPWR sky130_fd_pr__pfet_01v8 ad=0.3 pd=1.6 as=0.6 ps=3.2 w=1 l=0.2
X8 newdene_0/AND_0/a_n2700_1720# clk VGND VGND sky130_fd_pr__nfet_01v8 ad=0.15 pd=1.1 as=0.3 ps=2.2 w=0.5 l=0.2
X9 VDPWR newdene_0/AND_0/b newdene_0/AND_0/a_n2700_2180# VDPWR sky130_fd_pr__pfet_01v8 ad=0.3 pd=1.6 as=0.3 ps=1.6 w=1 l=0.2
X10 newdene_0/AND_0/out newdene_0/AND_0/a_n2700_2180# VDPWR VDPWR sky130_fd_pr__pfet_01v8 ad=0.6 pd=3.2 as=0.3 ps=1.6 w=1 l=0.2
X11 newdene_0/AND_0/out newdene_0/AND_0/a_n2700_2180# VGND VGND sky130_fd_pr__nfet_01v8 ad=0.3 pd=2.2 as=0.3 ps=2.2 w=0.5 l=0.2
X12 newdene_0/AND_0/a_n2700_2180# newdene_0/AND_0/b newdene_0/AND_0/a_n2700_1720# VGND sky130_fd_pr__nfet_01v8 ad=0.3 pd=2.2 as=0.15 ps=1.1 w=0.5 l=0.2
X13 VDPWR newdene_0/sw3cs_0/a_n260_n6040# newdene_0/sw3cs_0/a_n540_n5100# VDPWR sky130_fd_pr__pfet_01v8 ad=1.8 pd=7.2 as=0.9 ps=3.6 w=3 l=0.15
X14 newdene_0/sw3cs_0/a_n540_n5100# newdene_0/li_7680_n13980# ua[0] VDPWR sky130_fd_pr__pfet_01v8 ad=3.6 pd=13.2 as=1.8 ps=6.6 w=6 l=0.15
X15 newdene_0/sw3cs_0/a_n540_n5100# newdene_0/li_7680_n13980# ua[0] VDPWR sky130_fd_pr__pfet_01v8 ad=1.8 pd=6.6 as=1.8 ps=6.6 w=6 l=0.15
X16 ua[0] newdene_0/li_7680_n13980# newdene_0/sw3cs_0/a_n540_n5100# VDPWR sky130_fd_pr__pfet_01v8 ad=1.8 pd=6.6 as=1.8 ps=6.6 w=6 l=0.15
X17 newdene_0/m2_4740_n7410# ui_in[0] newdene_0/sw3cs_0/a_n260_n6040# VGND sky130_fd_pr__nfet_01v8 ad=3.6 pd=13.2 as=3.6 ps=13.2 w=6 l=0.15
X18 ua[0] newdene_0/li_7680_n13980# newdene_0/sw3cs_0/a_n540_n5100# VDPWR sky130_fd_pr__pfet_01v8 ad=1.8 pd=6.6 as=1.8 ps=6.6 w=6 l=0.15
X19 VDPWR newdene_0/sw3cs_0/a_n260_n6040# newdene_0/sw3cs_0/a_n540_n5100# VDPWR sky130_fd_pr__pfet_01v8 ad=0.9 pd=3.6 as=1.8 ps=7.2 w=3 l=0.15
X20 VDPWR ui_in[0] newdene_0/sw3cs_0/a_n260_n6040# VDPWR sky130_fd_pr__pfet_01v8 ad=1.2 pd=5.2 as=1.2 ps=5.2 w=2 l=0.15
X21 newdene_0/sw3cs_0/a_n540_n5100# newdene_0/li_7680_n13980# ua[0] VDPWR sky130_fd_pr__pfet_01v8 ad=1.8 pd=6.6 as=3.6 ps=13.2 w=6 l=0.15
X22 newdene_0/sw3cs_0/a_n540_n5100# newdene_0/sw3cs_0/a_n260_n6040# VDPWR VDPWR sky130_fd_pr__pfet_01v8 ad=0.9 pd=3.6 as=0.9 ps=3.6 w=3 l=0.15
X23 newdene_0/li_5730_n12230# newdene_0/a_1120_n13160# newdene_0/2nand1_0/a_160_n1540# VGND sky130_fd_pr__nfet_01v8 ad=3.5 pd=15 as=3.5 ps=15 w=7 l=0.4
X24 VDPWR newdene_0/a_1120_n13160# newdene_0/li_5730_n12230# VDPWR sky130_fd_pr__pfet_01v8 ad=4.9 pd=20.6 as=5.155 ps=19.2 w=9.8 l=0.4
X25 newdene_0/2nand1_0/a_160_n1540# newdene_0/a_5450_n12190# VGND VGND sky130_fd_pr__nfet_01v8 ad=3.5 pd=15 as=3.5 ps=15 w=7 l=0.4
X26 newdene_0/li_5730_n12230# newdene_0/a_5450_n12190# VDPWR VDPWR sky130_fd_pr__pfet_01v8 ad=5.155 pd=19.2 as=4.9 ps=20.6 w=9.8 l=0.4
X27 newdene_0/compnew_0/a_n542_2160# ua[0] newdene_0/compnew_0/a_158_4380# VDPWR sky130_fd_pr__pfet_01v8 ad=6 pd=21.2 as=6 ps=21.2 w=10 l=0.15
X28 newdene_0/AND_0/b newdene_0/compnew_0/a_n202_2520# newdene_0/compnew_0/a_898_2120# VDPWR sky130_fd_pr__pfet_01v8 ad=2.6 pd=9.3 as=2.6 ps=9.3 w=4 l=0.4
X29 VDPWR newdene_0/compnew_0/a_n1102_2520# newdene_0/compnew_0/a_n1102_2520# VDPWR sky130_fd_pr__pfet_01v8 ad=0.6 pd=3.2 as=0.6 ps=3.2 w=1 l=0.2
X30 newdene_0/compnew_0/a_n122_5000# newdene_0/compnew_0/a_n122_5000# VGND VGND sky130_fd_pr__nfet_01v8 ad=3 pd=11.2 as=3 ps=11.2 w=5 l=0.15
X31 VGND newdene_0/compnew_0/a_n122_5000# newdene_0/compnew_0/a_n202_2520# VGND sky130_fd_pr__nfet_01v8 ad=3 pd=11.2 as=3 ps=11.2 w=5 l=0.15
X32 newdene_0/compnew_0/a_n982_2480# newdene_0/compnew_0/a_n982_2480# newdene_0/compnew_0/a_n1102_2520# VDPWR sky130_fd_pr__pfet_01v8 ad=1.8 pd=7.2 as=1.8 ps=7.2 w=3 l=0.2
X33 newdene_0/compnew_0/a_n422_2080# newdene_0/compnew_0/a_n82_2480# newdene_0/compnew_0/a_n202_2520# VDPWR sky130_fd_pr__pfet_01v8 ad=2.4 pd=9.2 as=2.4 ps=9.2 w=4 l=0.15
X34 newdene_0/compnew_0/a_n82_2480# newdene_0/compnew_0/a_158_4380# VGND VGND sky130_fd_pr__nfet_01v8 ad=1.2 pd=5.2 as=1.2 ps=5.2 w=2 l=0.2
X35 VDPWR newdene_0/compnew_0/a_n422_2080# newdene_0/compnew_0/a_n542_2160# VDPWR sky130_fd_pr__pfet_01v8 ad=4.8 pd=17.2 as=2.4 ps=8.6 w=8 l=0.15
X36 newdene_0/compnew_0/a_n422_2080# newdene_0/compnew_0/a_n422_2080# VDPWR VDPWR sky130_fd_pr__pfet_01v8 ad=0.6 pd=3.2 as=0.6 ps=3.2 w=1 l=0.15
X37 VDPWR newdene_0/compnew_0/a_n202_2520# newdene_0/compnew_0/a_898_2120# VDPWR sky130_fd_pr__pfet_01v8 ad=2.6 pd=9.3 as=2.6 ps=9.3 w=4 l=0.4
X38 VGND newdene_0/compnew_0/a_n1102_3300# newdene_0/compnew_0/a_n1102_3300# VGND sky130_fd_pr__nfet_01v8 ad=0.6 pd=3.2 as=0.6 ps=3.2 w=1 l=0.2
X39 VGND newdene_0/compnew_0/a_158_4380# newdene_0/compnew_0/a_158_4380# VGND sky130_fd_pr__nfet_01v8 ad=1.2 pd=5.2 as=1.2 ps=5.2 w=2 l=0.2
X40 newdene_0/compnew_0/a_n542_2160# newdene_0/compnew_0/a_n1102_2520# VDPWR VDPWR sky130_fd_pr__pfet_01v8 ad=2.4 pd=8.6 as=4.8 ps=17.2 w=8 l=0.15
X41 newdene_0/AND_0/b newdene_0/compnew_0/a_n202_2520# newdene_0/compnew_0/a_898_4180# VGND sky130_fd_pr__nfet_01v8 ad=1.3 pd=5.3 as=1.3 ps=5.3 w=2 l=0.4
X42 newdene_0/compnew_0/a_n122_5000# newdene_0/compnew_0/a_n122_5000# newdene_0/compnew_0/a_1538_2000# VDPWR sky130_fd_pr__pfet_01v8 ad=2.4 pd=9.2 as=2.4 ps=9.2 w=4 l=0.15
X43 VGND newdene_0/compnew_0/a_n202_2520# newdene_0/compnew_0/a_898_4180# VGND sky130_fd_pr__nfet_01v8 ad=1.3 pd=5.3 as=1.3 ps=5.3 w=2 l=0.4
X44 newdene_0/compnew_0/a_n982_2480# newdene_0/compnew_0/a_n982_2480# newdene_0/compnew_0/a_n1102_3300# VGND sky130_fd_pr__nfet_01v8 ad=0.6 pd=3.2 as=0.6 ps=3.2 w=1 l=0.2
X45 newdene_0/compnew_0/a_n82_2480# ua[1] newdene_0/compnew_0/a_n542_2160# VDPWR sky130_fd_pr__pfet_01v8 ad=6 pd=21.2 as=6 ps=21.2 w=10 l=0.15
X46 VDPWR newdene_0/compnew_0/a_1538_2000# newdene_0/compnew_0/a_1538_2000# VDPWR sky130_fd_pr__pfet_01v8 ad=2.4 pd=9.2 as=2.4 ps=9.2 w=4 l=0.15
X47 newdene_0/m2_4740_n7410# ui_in[1] newdene_0/sw2cs_0/a_n920_2040# VGND sky130_fd_pr__nfet_01v8 ad=2.4 pd=9.2 as=2.4 ps=9.2 w=4 l=0.2
X48 VDPWR ui_in[1] newdene_0/sw2cs_0/a_n920_2040# VDPWR sky130_fd_pr__pfet_01v8 ad=1.2 pd=5.2 as=1.2 ps=5.2 w=2 l=0.2
X49 newdene_0/sw2cs_0/a_n1040_2110# newdene_0/li_7690_n11680# ua[0] VDPWR sky130_fd_pr__pfet_01v8 ad=1.5 pd=6.2 as=0.75 ps=3.1 w=2.5 l=0.15
X50 VDPWR newdene_0/sw2cs_0/a_n920_2040# newdene_0/sw2cs_0/a_n1040_2110# VDPWR sky130_fd_pr__pfet_01v8 ad=1.23 pd=5.3 as=0.615 ps=2.65 w=2.05 l=0.15
X51 ua[0] newdene_0/li_7690_n11680# newdene_0/sw2cs_0/a_n1040_2110# VDPWR sky130_fd_pr__pfet_01v8 ad=0.75 pd=3.1 as=0.75 ps=3.1 w=2.5 l=0.15
X52 newdene_0/sw2cs_0/a_n1040_2110# newdene_0/li_7690_n11680# ua[0] VDPWR sky130_fd_pr__pfet_01v8 ad=0.75 pd=3.1 as=1.5 ps=6.2 w=2.5 l=0.15
X53 VDPWR newdene_0/sw2cs_0/a_n920_2040# newdene_0/sw2cs_0/a_n1040_2110# VDPWR sky130_fd_pr__pfet_01v8 ad=0.615 pd=2.65 as=1.23 ps=5.3 w=2.05 l=0.15
X54 newdene_0/sw2cs_0/a_n1040_2110# newdene_0/sw2cs_0/a_n920_2040# VDPWR VDPWR sky130_fd_pr__pfet_01v8 ad=0.615 pd=2.65 as=0.615 ps=2.65 w=2.05 l=0.15
X55 newdene_0/pulsedelay_0/a_998_460# newdene_0/pulsedelay_0/a_698_460# newdene_0/pulsedelay_0/a_868_n300# VGND sky130_fd_pr__nfet_01v8 ad=1 pd=5 as=1 ps=5 w=2 l=0.15
X56 newdene_0/pulsedelay_0/a_268_n300# newdene_0/m2_1930_n14060# VGND VGND sky130_fd_pr__nfet_01v8 ad=1.5 pd=7 as=1.5 ps=7 w=3 l=0.15
X57 VGND newdene_0/pulsedelay_0/a_268_n300# newdene_0/pulsedelay_0/a_268_n300# VGND sky130_fd_pr__nfet_01v8 ad=2.25 pd=10 as=2.25 ps=10 w=4.5 l=0.15
X58 newdene_0/pulsedelay_0/a_1468_n300# newdene_0/m2_1930_n14060# VGND VGND sky130_fd_pr__nfet_01v8 ad=1.5 pd=7 as=1.5 ps=7 w=3 l=0.15
X59 newdene_0/pulsedelay_0/a_998_460# newdene_0/pulsedelay_0/a_698_460# VDPWR VDPWR sky130_fd_pr__pfet_01v8 ad=2.5 pd=11 as=2.5 ps=11 w=5 l=0.15
X60 VGND newdene_0/pulsedelay_0/a_1468_n300# newdene_0/pulsedelay_0/a_1468_n300# VGND sky130_fd_pr__nfet_01v8 ad=2.25 pd=10 as=2.25 ps=10 w=4.5 l=0.15
X61 newdene_0/pulsedelay_0/a_1298_460# newdene_0/pulsedelay_0/a_998_460# VGND VGND sky130_fd_pr__nfet_01v8 ad=1 pd=5 as=1 ps=5 w=2 l=0.15
X62 newdene_0/pulsedelay_0/a_1298_460# newdene_0/pulsedelay_0/a_998_460# VDPWR VDPWR sky130_fd_pr__pfet_01v8 ad=2.5 pd=11 as=2.5 ps=11 w=5 l=0.15
X63 newdene_0/a_5450_n12190# newdene_0/pulsedelay_0/a_1298_460# newdene_0/pulsedelay_0/a_1468_n300# VGND sky130_fd_pr__nfet_01v8 ad=1 pd=5 as=1 ps=5 w=2 l=0.15
X64 newdene_0/pulsedelay_0/a_398_460# newdene_0/a_1120_n13160# VDPWR VDPWR sky130_fd_pr__pfet_01v8 ad=2.5 pd=11 as=2.5 ps=11 w=5 l=0.15
X65 newdene_0/pulsedelay_0/a_868_n300# newdene_0/m2_1930_n14060# VGND VGND sky130_fd_pr__nfet_01v8 ad=1.5 pd=7 as=1.5 ps=7 w=3 l=0.15
X66 VGND newdene_0/pulsedelay_0/a_868_n300# newdene_0/pulsedelay_0/a_868_n300# VGND sky130_fd_pr__nfet_01v8 ad=2.25 pd=10 as=2.25 ps=10 w=4.5 l=0.15
X67 newdene_0/a_5450_n12190# newdene_0/pulsedelay_0/a_1298_460# VDPWR VDPWR sky130_fd_pr__pfet_01v8 ad=2.5 pd=11 as=2.5 ps=11 w=5 l=0.15
X68 newdene_0/pulsedelay_0/a_698_460# newdene_0/pulsedelay_0/a_398_460# VDPWR VDPWR sky130_fd_pr__pfet_01v8 ad=2.5 pd=11 as=2.5 ps=11 w=5 l=0.15
X69 newdene_0/pulsedelay_0/a_398_460# newdene_0/a_1120_n13160# newdene_0/pulsedelay_0/a_268_n300# VGND sky130_fd_pr__nfet_01v8 ad=1 pd=5 as=1 ps=5 w=2 l=0.15
X70 newdene_0/pulsedelay_0/a_698_460# newdene_0/pulsedelay_0/a_398_460# VGND VGND sky130_fd_pr__nfet_01v8 ad=1 pd=5 as=1 ps=5 w=2 l=0.15
X71 newdene_0/pdvc_0/a_4840_n760# ui_in[5] VDPWR VDPWR sky130_fd_pr__pfet_01v8 ad=2.58 pd=9.8 as=2.58 ps=9.8 w=4.3 l=4
X72 newdene_0/pdvc_0/a_4840_n760# newdene_0/m2_1930_n14060# newdene_0/AND_0/b VGND sky130_fd_pr__nfet_01v8 ad=1.8 pd=7.2 as=1.8 ps=7.2 w=3 l=0.2
X73 newdene_0/AND_0/b newdene_0/AND_0/b VGND VGND sky130_fd_pr__nfet_01v8 ad=1.8 pd=7.2 as=1.8 ps=7.2 w=3 l=5
X74 VDPWR ui_in[4] newdene_0/pdvc_0/a_4840_n760# VDPWR sky130_fd_pr__pfet_01v8 ad=1.8 pd=7.2 as=1.8 ps=7.2 w=3 l=4
X75 newdene_0/pdvc_0/a_4840_n760# ui_in[3] VDPWR VDPWR sky130_fd_pr__pfet_01v8 ad=0.6 pd=3.2 as=0.6 ps=3.2 w=1 l=4
X76 VDPWR ui_in[6] newdene_0/pdvc_0/a_4840_n760# VDPWR sky130_fd_pr__pfet_01v8 ad=3.6 pd=13.2 as=3.6 ps=13.2 w=6 l=4
X77 newdene_0/counnew_0/a_n6192_13338# rst_n newdene_0/counnew_0/a_n5912_14878# newdene_0/counnew_0/gnd sky130_fd_pr__nfet_01v8 ad=0.6 pd=3.2 as=0.3 ps=1.6 w=1 l=0.3
X78 newdene_0/counnew_0/a_4928_12918# newdene_0/counnew_0/a_4188_13478# newdene_0/counnew_0/gnd newdene_0/counnew_0/gnd sky130_fd_pr__nfet_01v8 ad=0.3 pd=1.6 as=0.6 ps=3.2 w=1 l=0.3
X79 newdene_0/counnew_0/a_8468_13478# newdene_0/counnew_0/a_8548_15878# newdene_0/counnew_0/a_8648_12918# newdene_0/counnew_0/gnd sky130_fd_pr__nfet_01v8 ad=0.6 pd=3.2 as=0.3 ps=1.6 w=1 l=0.3
X80 newdene_0/counnew_0/a_2788_14218# uo_out[3] VDPWR VDPWR sky130_fd_pr__pfet_01v8 ad=0.45 pd=2.1 as=0.9 ps=4.2 w=1.5 l=0.3
X81 VDPWR newdene_0/counnew_0/a_n1852_16918# newdene_0/counnew_0/a_n2152_15878# VDPWR sky130_fd_pr__pfet_01v8 ad=0.45 pd=2.1 as=0.45 ps=2.1 w=1.5 l=0.3
X82 newdene_0/counnew_0/a_6228_13338# rst_n VDPWR VDPWR sky130_fd_pr__pfet_01v8 ad=0.9 pd=4.2 as=0.45 ps=2.1 w=1.5 l=0.3
X83 newdene_0/counnew_0/a_4188_14878# newdene_0/counnew_0/a_4088_14578# newdene_0/counnew_0/gnd newdene_0/counnew_0/gnd sky130_fd_pr__nfet_01v8 ad=0.3 pd=1.6 as=0.6 ps=3.2 w=1 l=0.3
X84 newdene_0/counnew_0/a_n2332_13338# newdene_0/counnew_0/a_n2332_14578# VDPWR VDPWR sky130_fd_pr__pfet_01v8 ad=0.45 pd=2.1 as=0.9 ps=4.2 w=1.5 l=0.3
X85 newdene_0/counnew_0/a_2788_15558# VDPWR newdene_0/counnew_0/gnd newdene_0/counnew_0/gnd sky130_fd_pr__nfet_01v8 ad=0.3 pd=1.6 as=0.6 ps=3.2 w=1 l=0.3
X86 newdene_0/counnew_0/a_9208_12918# newdene_0/counnew_0/a_8468_13478# newdene_0/counnew_0/gnd newdene_0/counnew_0/gnd sky130_fd_pr__nfet_01v8 ad=0.3 pd=1.6 as=0.6 ps=3.2 w=1 l=0.3
X87 newdene_0/counnew_0/a_6228_14578# newdene_0/counnew_0/a_6228_13338# newdene_0/counnew_0/a_6508_15558# newdene_0/counnew_0/gnd sky130_fd_pr__nfet_01v8 ad=0.6 pd=3.2 as=0.3 ps=1.6 w=1 l=0.3
X88 newdene_0/counnew_0/a_4088_14578# newdene_0/counnew_0/a_4088_13338# VDPWR VDPWR sky130_fd_pr__pfet_01v8 ad=0.9 pd=4.2 as=0.45 ps=2.1 w=1.5 l=0.3
X89 newdene_0/counnew_0/a_7068_14218# uo_out[1] VDPWR VDPWR sky130_fd_pr__pfet_01v8 ad=0.45 pd=2.1 as=0.9 ps=4.2 w=1.5 l=0.3
X90 newdene_0/counnew_0/a_n2232_15558# VDPWR newdene_0/counnew_0/gnd newdene_0/counnew_0/gnd sky130_fd_pr__nfet_01v8 ad=0.3 pd=1.6 as=0.6 ps=3.2 w=1 l=0.3
X91 newdene_0/counnew_0/a_9208_14218# rst_n newdene_0/counnew_0/a_9388_14878# newdene_0/counnew_0/gnd sky130_fd_pr__nfet_01v8 ad=0.6 pd=3.2 as=0.3 ps=1.6 w=1 l=0.3
X92 newdene_0/counnew_0/a_7068_15558# VDPWR newdene_0/counnew_0/gnd newdene_0/counnew_0/gnd sky130_fd_pr__nfet_01v8 ad=0.3 pd=1.6 as=0.6 ps=3.2 w=1 l=0.3
X93 newdene_0/counnew_0/a_n5872_16918# newdene_0/counnew_0/a_n6252_16918# VDPWR VDPWR sky130_fd_pr__pfet_01v8 ad=0.75 pd=3.1 as=1.5 ps=6.2 w=2.5 l=0.2
X94 newdene_0/counnew_0/a_n192_13338# newdene_0/counnew_0/a_n192_14578# VDPWR VDPWR sky130_fd_pr__pfet_01v8 ad=0.45 pd=2.1 as=0.9 ps=4.2 w=1.5 l=0.3
X95 VDPWR newdene_0/counnew_0/a_n6012_15878# newdene_0/counnew_0/a_n6192_14578# VDPWR sky130_fd_pr__pfet_01v8 ad=0.45 pd=2.1 as=0.45 ps=2.1 w=1.5 l=0.3
X96 newdene_0/counnew_0/a_n92_15558# VDPWR newdene_0/counnew_0/gnd newdene_0/counnew_0/gnd sky130_fd_pr__nfet_01v8 ad=0.3 pd=1.6 as=0.6 ps=3.2 w=1 l=0.3
X97 newdene_0/counnew_0/a_8848_16918# uo_out[0] newdene_0/counnew_0/a_8688_16918# VDPWR sky130_fd_pr__pfet_01v8 ad=1.5 pd=6.2 as=0.75 ps=3.1 w=2.5 l=0.2
X98 newdene_0/counnew_0/a_n12_15878# rst_n VDPWR VDPWR sky130_fd_pr__pfet_01v8 ad=0.9 pd=4.2 as=0.45 ps=2.1 w=1.5 l=0.3
X99 VDPWR uo_out[7] newdene_0/counnew_0/a_n5252_16878# VDPWR sky130_fd_pr__pfet_01v8 ad=1.5 pd=6.2 as=1.5 ps=6.2 w=2.5 l=0.2
X100 newdene_0/counnew_0/a_n4192_12918# newdene_0/AND_0/out newdene_0/counnew_0/a_n4372_12918# newdene_0/counnew_0/gnd sky130_fd_pr__nfet_01v8 ad=0.3 pd=1.6 as=0.3 ps=1.6 w=1 l=0.3
X101 VDPWR newdene_0/AND_0/out newdene_0/counnew_0/a_n2332_13338# VDPWR sky130_fd_pr__pfet_01v8 ad=0.45 pd=2.1 as=0.45 ps=2.1 w=1.5 l=0.3
X102 VDPWR newdene_0/counnew_0/a_4268_15878# newdene_0/counnew_0/a_4088_14578# VDPWR sky130_fd_pr__pfet_01v8 ad=0.45 pd=2.1 as=0.45 ps=2.1 w=1.5 l=0.3
X103 newdene_0/counnew_0/a_n2052_15558# newdene_0/counnew_0/a_n2152_15878# newdene_0/counnew_0/a_n2232_15558# newdene_0/counnew_0/gnd sky130_fd_pr__nfet_01v8 ad=0.3 pd=1.6 as=0.3 ps=1.6 w=1 l=0.3
X104 newdene_0/counnew_0/a_n2392_16918# newdene_0/counnew_0/a_n2912_18858# VDPWR VDPWR sky130_fd_pr__pfet_01v8 ad=1.5 pd=6.2 as=1.5 ps=6.2 w=2.5 l=0.2
X105 newdene_0/counnew_0/a_3508_18858# newdene_0/counnew_0/a_3188_18858# VDPWR VDPWR sky130_fd_pr__pfet_01v8 ad=0.72 pd=3.6 as=0.36 ps=1.8 w=1.2 l=0.2
X106 newdene_0/counnew_0/a_n3232_18478# uo_out[7] newdene_0/counnew_0/gnd newdene_0/counnew_0/gnd sky130_fd_pr__nfet_01v8 ad=0.21 pd=1.3 as=0.42 ps=2.6 w=0.7 l=0.2
X107 newdene_0/counnew_0/a_n6092_13478# newdene_0/counnew_0/a_n6012_15878# VDPWR VDPWR sky130_fd_pr__pfet_01v8 ad=0.9 pd=4.2 as=0.45 ps=2.1 w=1.5 l=0.3
X108 newdene_0/counnew_0/a_n192_13338# rst_n VDPWR VDPWR sky130_fd_pr__pfet_01v8 ad=0.9 pd=4.2 as=0.45 ps=2.1 w=1.5 l=0.3
X109 newdene_0/counnew_0/a_5648_18858# newdene_0/counnew_0/a_5328_18858# newdene_0/counnew_0/gnd newdene_0/counnew_0/gnd sky130_fd_pr__nfet_01v8 ad=0.42 pd=2.6 as=0.42 ps=2.6 w=0.7 l=0.2
X110 newdene_0/counnew_0/a_n192_14578# newdene_0/counnew_0/a_n192_13338# newdene_0/counnew_0/a_88_15558# newdene_0/counnew_0/gnd sky130_fd_pr__nfet_01v8 ad=0.6 pd=3.2 as=0.3 ps=1.6 w=1 l=0.3
X111 newdene_0/counnew_0/a_2228_14878# newdene_0/AND_0/out newdene_0/counnew_0/a_2048_14878# newdene_0/counnew_0/gnd sky130_fd_pr__nfet_01v8 ad=0.3 pd=1.6 as=0.3 ps=1.6 w=1 l=0.3
X112 newdene_0/counnew_0/a_4188_13478# newdene_0/counnew_0/a_4088_13338# VDPWR VDPWR sky130_fd_pr__pfet_01v8 ad=0.45 pd=2.1 as=0.9 ps=4.2 w=1.5 l=0.3
X113 newdene_0/counnew_0/a_7248_12918# newdene_0/counnew_0/a_6708_16918# newdene_0/counnew_0/a_7068_12918# newdene_0/counnew_0/gnd sky130_fd_pr__nfet_01v8 ad=0.3 pd=1.6 as=0.3 ps=1.6 w=1 l=0.3
X114 uo_out[4] VDPWR VDPWR VDPWR sky130_fd_pr__pfet_01v8 ad=0.45 pd=2.1 as=0.9 ps=4.2 w=1.5 l=0.3
X115 newdene_0/counnew_0/a_628_17818# newdene_0/counnew_0/a_n252_16918# newdene_0/counnew_0/a_288_16918# newdene_0/counnew_0/gnd sky130_fd_pr__nfet_01v8 ad=0.3 pd=1.6 as=0.6 ps=3.2 w=1 l=0.2
X116 newdene_0/counnew_0/a_n6092_12918# newdene_0/counnew_0/a_n6192_13338# newdene_0/counnew_0/gnd newdene_0/counnew_0/gnd sky130_fd_pr__nfet_01v8 ad=0.3 pd=1.6 as=0.6 ps=3.2 w=1 l=0.3
X117 VDPWR newdene_0/counnew_0/a_4188_13478# newdene_0/counnew_0/a_4928_14218# VDPWR sky130_fd_pr__pfet_01v8 ad=0.45 pd=2.1 as=0.45 ps=2.1 w=1.5 l=0.3
X118 newdene_0/counnew_0/a_8548_15878# rst_n VDPWR VDPWR sky130_fd_pr__pfet_01v8 ad=0.9 pd=4.2 as=0.45 ps=2.1 w=1.5 l=0.3
X119 newdene_0/counnew_0/a_n2332_14578# newdene_0/counnew_0/a_n2332_13338# VDPWR VDPWR sky130_fd_pr__pfet_01v8 ad=0.9 pd=4.2 as=0.45 ps=2.1 w=1.5 l=0.3
X120 newdene_0/counnew_0/a_5108_15558# newdene_0/counnew_0/a_4088_13338# newdene_0/counnew_0/a_4928_15558# newdene_0/counnew_0/gnd sky130_fd_pr__nfet_01v8 ad=0.3 pd=1.6 as=0.3 ps=1.6 w=1 l=0.3
X121 newdene_0/counnew_0/a_8648_14878# newdene_0/AND_0/out newdene_0/counnew_0/a_8468_14878# newdene_0/counnew_0/gnd sky130_fd_pr__nfet_01v8 ad=0.3 pd=1.6 as=0.3 ps=1.6 w=1 l=0.3
X122 newdene_0/counnew_0/a_n5352_14218# rst_n VDPWR VDPWR sky130_fd_pr__pfet_01v8 ad=0.9 pd=4.2 as=0.45 ps=2.1 w=1.5 l=0.3
X123 VDPWR uo_out[2] newdene_0/counnew_0/a_5028_16878# VDPWR sky130_fd_pr__pfet_01v8 ad=1.5 pd=6.2 as=1.5 ps=6.2 w=2.5 l=0.2
X124 uo_out[7] newdene_0/counnew_0/a_n5352_14218# newdene_0/counnew_0/a_n5172_15558# newdene_0/counnew_0/gnd sky130_fd_pr__nfet_01v8 ad=0.6 pd=3.2 as=0.3 ps=1.6 w=1 l=0.3
X125 newdene_0/counnew_0/a_2788_12918# newdene_0/counnew_0/a_2048_13478# newdene_0/counnew_0/gnd newdene_0/counnew_0/gnd sky130_fd_pr__nfet_01v8 ad=0.3 pd=1.6 as=0.6 ps=3.2 w=1 l=0.3
X126 newdene_0/counnew_0/a_6328_13478# newdene_0/counnew_0/a_6408_15878# newdene_0/counnew_0/a_6508_12918# newdene_0/counnew_0/gnd sky130_fd_pr__nfet_01v8 ad=0.6 pd=3.2 as=0.3 ps=1.6 w=1 l=0.3
X127 newdene_0/counnew_0/a_4028_16918# newdene_0/counnew_0/a_3508_18858# VDPWR VDPWR sky130_fd_pr__pfet_01v8 ad=1.5 pd=6.2 as=1.5 ps=6.2 w=2.5 l=0.2
X128 newdene_0/counnew_0/a_n2232_12918# newdene_0/counnew_0/a_n2332_13338# newdene_0/counnew_0/gnd newdene_0/counnew_0/gnd sky130_fd_pr__nfet_01v8 ad=0.3 pd=1.6 as=0.6 ps=3.2 w=1 l=0.3
X129 newdene_0/counnew_0/a_1948_14578# newdene_0/counnew_0/a_1948_13338# VDPWR VDPWR sky130_fd_pr__pfet_01v8 ad=0.9 pd=4.2 as=0.45 ps=2.1 w=1.5 l=0.3
X130 newdene_0/counnew_0/a_7068_12918# newdene_0/counnew_0/a_6328_13478# newdene_0/counnew_0/gnd newdene_0/counnew_0/gnd sky130_fd_pr__nfet_01v8 ad=0.3 pd=1.6 as=0.6 ps=3.2 w=1 l=0.3
X131 newdene_0/counnew_0/a_8308_16918# newdene_0/counnew_0/a_7788_18858# VDPWR VDPWR sky130_fd_pr__pfet_01v8 ad=1.5 pd=6.2 as=1.5 ps=6.2 w=2.5 l=0.2
X132 newdene_0/counnew_0/a_4408_16918# newdene_0/counnew_0/a_4028_16918# VDPWR VDPWR sky130_fd_pr__pfet_01v8 ad=0.75 pd=3.1 as=1.5 ps=6.2 w=2.5 l=0.2
X133 newdene_0/counnew_0/a_n1492_14218# rst_n VDPWR VDPWR sky130_fd_pr__pfet_01v8 ad=0.9 pd=4.2 as=0.45 ps=2.1 w=1.5 l=0.3
X134 newdene_0/counnew_0/a_n2912_18858# newdene_0/counnew_0/a_n3232_18858# VDPWR VDPWR sky130_fd_pr__pfet_01v8 ad=0.72 pd=3.6 as=0.36 ps=1.8 w=1.2 l=0.2
X135 newdene_0/counnew_0/a_n3632_14878# uo_out[6] newdene_0/counnew_0/gnd newdene_0/counnew_0/gnd sky130_fd_pr__nfet_01v8 ad=0.3 pd=1.6 as=0.6 ps=3.2 w=1 l=0.3
X136 VDPWR newdene_0/AND_0/out newdene_0/counnew_0/a_n192_13338# VDPWR sky130_fd_pr__pfet_01v8 ad=0.45 pd=2.1 as=0.45 ps=2.1 w=1.5 l=0.3
X137 uo_out[5] newdene_0/counnew_0/a_n1492_14218# newdene_0/counnew_0/a_n1312_15558# newdene_0/counnew_0/gnd sky130_fd_pr__nfet_01v8 ad=0.6 pd=3.2 as=0.3 ps=1.6 w=1 l=0.3
X138 newdene_0/counnew_0/a_8468_14878# newdene_0/counnew_0/a_8368_14578# newdene_0/counnew_0/gnd newdene_0/counnew_0/gnd sky130_fd_pr__nfet_01v8 ad=0.3 pd=1.6 as=0.6 ps=3.2 w=1 l=0.3
X139 newdene_0/counnew_0/a_n92_12918# newdene_0/counnew_0/a_n192_13338# newdene_0/counnew_0/gnd newdene_0/counnew_0/gnd sky130_fd_pr__nfet_01v8 ad=0.3 pd=1.6 as=0.6 ps=3.2 w=1 l=0.3
X140 newdene_0/counnew_0/a_88_15558# newdene_0/counnew_0/a_n12_15878# newdene_0/counnew_0/a_n92_15558# newdene_0/counnew_0/gnd sky130_fd_pr__nfet_01v8 ad=0.3 pd=1.6 as=0.3 ps=1.6 w=1 l=0.3
X141 newdene_0/counnew_0/a_4908_17818# newdene_0/counnew_0/a_4028_16918# newdene_0/counnew_0/a_4568_16918# newdene_0/counnew_0/gnd sky130_fd_pr__nfet_01v8 ad=0.3 pd=1.6 as=0.6 ps=3.2 w=1 l=0.2
X142 newdene_0/counnew_0/a_n4472_13338# rst_n newdene_0/counnew_0/a_n4192_14878# newdene_0/counnew_0/gnd sky130_fd_pr__nfet_01v8 ad=0.6 pd=3.2 as=0.3 ps=1.6 w=1 l=0.3
X143 newdene_0/counnew_0/a_8368_14578# newdene_0/counnew_0/a_8368_13338# VDPWR VDPWR sky130_fd_pr__pfet_01v8 ad=0.9 pd=4.2 as=0.45 ps=2.1 w=1.5 l=0.3
X144 uo_out[2] VDPWR VDPWR VDPWR sky130_fd_pr__pfet_01v8 ad=0.45 pd=2.1 as=0.9 ps=4.2 w=1.5 l=0.3
X145 newdene_0/counnew_0/a_n772_18858# newdene_0/counnew_0/a_n1092_18858# VDPWR VDPWR sky130_fd_pr__pfet_01v8 ad=0.72 pd=3.6 as=0.36 ps=1.8 w=1.2 l=0.2
X146 newdene_0/counnew_0/a_9188_17818# newdene_0/counnew_0/a_8308_16918# newdene_0/counnew_0/a_8848_16918# newdene_0/counnew_0/gnd sky130_fd_pr__nfet_01v8 ad=0.3 pd=1.6 as=0.6 ps=3.2 w=1 l=0.2
X147 uo_out[0] VDPWR VDPWR VDPWR sky130_fd_pr__pfet_01v8 ad=0.45 pd=2.1 as=0.9 ps=4.2 w=1.5 l=0.3
X148 newdene_0/counnew_0/a_2428_16918# newdene_0/counnew_0/a_1368_18858# newdene_0/counnew_0/a_2268_17818# newdene_0/counnew_0/gnd sky130_fd_pr__nfet_01v8 ad=0.6 pd=3.2 as=0.3 ps=1.6 w=1 l=0.2
X149 newdene_0/counnew_0/a_n2052_12918# newdene_0/AND_0/out newdene_0/counnew_0/a_n2232_12918# newdene_0/counnew_0/gnd sky130_fd_pr__nfet_01v8 ad=0.3 pd=1.6 as=0.3 ps=1.6 w=1 l=0.3
X150 newdene_0/counnew_0/gnd newdene_0/counnew_0/a_n5252_16878# newdene_0/counnew_0/a_n5372_17818# newdene_0/counnew_0/gnd sky130_fd_pr__nfet_01v8 ad=0.6 pd=3.2 as=0.3 ps=1.6 w=1 l=0.2
X151 VDPWR newdene_0/counnew_0/a_n92_13478# newdene_0/counnew_0/a_648_14218# VDPWR sky130_fd_pr__pfet_01v8 ad=0.45 pd=2.1 as=0.45 ps=2.1 w=1.5 l=0.3
X152 VDPWR newdene_0/AND_0/out newdene_0/counnew_0/a_2048_13478# VDPWR sky130_fd_pr__pfet_01v8 ad=0.45 pd=2.1 as=0.45 ps=2.1 w=1.5 l=0.3
X153 newdene_0/counnew_0/a_n6252_16918# VDPWR newdene_0/counnew_0/gnd newdene_0/counnew_0/gnd sky130_fd_pr__nfet_01v8 ad=0.6 pd=3.2 as=0.6 ps=3.2 w=1 l=0.2
X154 newdene_0/counnew_0/a_828_15558# newdene_0/counnew_0/a_n192_13338# newdene_0/counnew_0/a_648_15558# newdene_0/counnew_0/gnd sky130_fd_pr__nfet_01v8 ad=0.3 pd=1.6 as=0.3 ps=1.6 w=1 l=0.3
X155 newdene_0/counnew_0/a_2788_14218# rst_n VDPWR VDPWR sky130_fd_pr__pfet_01v8 ad=0.9 pd=4.2 as=0.45 ps=2.1 w=1.5 l=0.3
X156 newdene_0/counnew_0/a_n3452_14878# newdene_0/counnew_0/a_n4372_13478# newdene_0/counnew_0/a_n3632_14878# newdene_0/counnew_0/gnd sky130_fd_pr__nfet_01v8 ad=0.3 pd=1.6 as=0.3 ps=1.6 w=1 l=0.3
X157 uo_out[3] newdene_0/counnew_0/a_2788_14218# newdene_0/counnew_0/a_2968_15558# newdene_0/counnew_0/gnd sky130_fd_pr__nfet_01v8 ad=0.6 pd=3.2 as=0.3 ps=1.6 w=1 l=0.3
X158 newdene_0/counnew_0/a_1368_18858# newdene_0/counnew_0/a_1048_18858# VDPWR VDPWR sky130_fd_pr__pfet_01v8 ad=0.72 pd=3.6 as=0.36 ps=1.8 w=1.2 l=0.2
X159 VDPWR newdene_0/AND_0/out newdene_0/counnew_0/a_8468_13478# VDPWR sky130_fd_pr__pfet_01v8 ad=0.45 pd=2.1 as=0.45 ps=2.1 w=1.5 l=0.3
X160 newdene_0/counnew_0/a_n92_13478# newdene_0/counnew_0/a_n12_15878# newdene_0/counnew_0/a_88_12918# newdene_0/counnew_0/gnd sky130_fd_pr__nfet_01v8 ad=0.6 pd=3.2 as=0.3 ps=1.6 w=1 l=0.3
X161 VDPWR newdene_0/counnew_0/a_n4292_15878# newdene_0/counnew_0/a_n4472_14578# VDPWR sky130_fd_pr__pfet_01v8 ad=0.45 pd=2.1 as=0.45 ps=2.1 w=1.5 l=0.3
X162 newdene_0/counnew_0/a_n1092_18478# newdene_0/counnew_0/a_n2912_18858# newdene_0/counnew_0/gnd newdene_0/counnew_0/gnd sky130_fd_pr__nfet_01v8 ad=0.21 pd=1.3 as=0.42 ps=2.6 w=0.7 l=0.2
X163 newdene_0/counnew_0/gnd newdene_0/counnew_0/a_n1392_16878# newdene_0/counnew_0/a_n1512_17818# newdene_0/counnew_0/gnd sky130_fd_pr__nfet_01v8 ad=0.6 pd=3.2 as=0.3 ps=1.6 w=1 l=0.2
X164 newdene_0/counnew_0/a_3508_18858# newdene_0/counnew_0/a_3188_18858# newdene_0/counnew_0/gnd newdene_0/counnew_0/gnd sky130_fd_pr__nfet_01v8 ad=0.42 pd=2.6 as=0.42 ps=2.6 w=0.7 l=0.2
X165 newdene_0/counnew_0/a_7788_18858# newdene_0/counnew_0/a_7468_18858# VDPWR VDPWR sky130_fd_pr__pfet_01v8 ad=0.72 pd=3.6 as=0.36 ps=1.8 w=1.2 l=0.2
X166 newdene_0/counnew_0/a_1048_18858# uo_out[4] newdene_0/counnew_0/a_1048_18478# newdene_0/counnew_0/gnd sky130_fd_pr__nfet_01v8 ad=0.42 pd=2.6 as=0.21 ps=1.3 w=0.7 l=0.2
X167 newdene_0/counnew_0/a_5108_12918# newdene_0/counnew_0/a_4568_16918# newdene_0/counnew_0/a_4928_12918# newdene_0/counnew_0/gnd sky130_fd_pr__nfet_01v8 ad=0.3 pd=1.6 as=0.3 ps=1.6 w=1 l=0.3
X168 newdene_0/counnew_0/a_n4292_15878# newdene_0/counnew_0/a_n4372_13478# VDPWR VDPWR sky130_fd_pr__pfet_01v8 ad=0.45 pd=2.1 as=0.9 ps=4.2 w=1.5 l=0.3
X169 newdene_0/counnew_0/a_n252_16918# newdene_0/counnew_0/a_n772_18858# newdene_0/counnew_0/gnd newdene_0/counnew_0/gnd sky130_fd_pr__nfet_01v8 ad=0.6 pd=3.2 as=0.6 ps=3.2 w=1 l=0.2
X170 newdene_0/counnew_0/a_n6012_15878# rst_n newdene_0/counnew_0/a_n5172_12918# newdene_0/counnew_0/gnd sky130_fd_pr__nfet_01v8 ad=0.6 pd=3.2 as=0.3 ps=1.6 w=1 l=0.3
X171 newdene_0/counnew_0/a_6508_14878# newdene_0/AND_0/out newdene_0/counnew_0/a_6328_14878# newdene_0/counnew_0/gnd sky130_fd_pr__nfet_01v8 ad=0.3 pd=1.6 as=0.3 ps=1.6 w=1 l=0.3
X172 VDPWR uo_out[3] newdene_0/counnew_0/a_2888_16878# VDPWR sky130_fd_pr__pfet_01v8 ad=1.5 pd=6.2 as=1.5 ps=6.2 w=2.5 l=0.2
X173 newdene_0/counnew_0/a_8468_13478# newdene_0/counnew_0/a_8368_13338# VDPWR VDPWR sky130_fd_pr__pfet_01v8 ad=0.45 pd=2.1 as=0.9 ps=4.2 w=1.5 l=0.3
X174 newdene_0/counnew_0/a_n5352_14878# uo_out[7] newdene_0/counnew_0/gnd newdene_0/counnew_0/gnd sky130_fd_pr__nfet_01v8 ad=0.3 pd=1.6 as=0.6 ps=3.2 w=1 l=0.3
X175 newdene_0/counnew_0/a_7468_18858# uo_out[1] newdene_0/counnew_0/a_7468_18478# newdene_0/counnew_0/gnd sky130_fd_pr__nfet_01v8 ad=0.42 pd=2.6 as=0.21 ps=1.3 w=0.7 l=0.2
X176 newdene_0/counnew_0/a_n4372_13478# newdene_0/counnew_0/a_n4292_15878# VDPWR VDPWR sky130_fd_pr__pfet_01v8 ad=0.9 pd=4.2 as=0.45 ps=2.1 w=1.5 l=0.3
X177 VDPWR newdene_0/counnew_0/a_8468_13478# newdene_0/counnew_0/a_9208_14218# VDPWR sky130_fd_pr__pfet_01v8 ad=0.45 pd=2.1 as=0.45 ps=2.1 w=1.5 l=0.3
X178 newdene_0/counnew_0/a_9388_15558# newdene_0/counnew_0/a_8368_13338# newdene_0/counnew_0/a_9208_15558# newdene_0/counnew_0/gnd sky130_fd_pr__nfet_01v8 ad=0.3 pd=1.6 as=0.3 ps=1.6 w=1 l=0.3
X179 VDPWR newdene_0/counnew_0/a_6228_13338# uo_out[1] VDPWR sky130_fd_pr__pfet_01v8 ad=0.45 pd=2.1 as=0.45 ps=2.1 w=1.5 l=0.3
X180 newdene_0/counnew_0/a_1888_16918# newdene_0/counnew_0/a_1368_18858# VDPWR VDPWR sky130_fd_pr__pfet_01v8 ad=1.5 pd=6.2 as=1.5 ps=6.2 w=2.5 l=0.2
X181 newdene_0/counnew_0/a_n6192_14578# VDPWR VDPWR VDPWR sky130_fd_pr__pfet_01v8 ad=0.45 pd=2.1 as=0.9 ps=4.2 w=1.5 l=0.3
X182 VDPWR uo_out[0] newdene_0/counnew_0/a_9308_16878# VDPWR sky130_fd_pr__pfet_01v8 ad=1.5 pd=6.2 as=1.5 ps=6.2 w=2.5 l=0.2
X183 VDPWR newdene_0/counnew_0/a_2888_16878# newdene_0/counnew_0/a_2768_16918# VDPWR sky130_fd_pr__pfet_01v8 ad=1.5 pd=6.2 as=0.75 ps=3.1 w=2.5 l=0.2
X184 newdene_0/counnew_0/a_n2152_15878# rst_n newdene_0/counnew_0/a_n1312_12918# newdene_0/counnew_0/gnd sky130_fd_pr__nfet_01v8 ad=0.6 pd=3.2 as=0.3 ps=1.6 w=1 l=0.3
X185 newdene_0/counnew_0/a_6168_16918# newdene_0/counnew_0/a_5648_18858# VDPWR VDPWR sky130_fd_pr__pfet_01v8 ad=1.5 pd=6.2 as=1.5 ps=6.2 w=2.5 l=0.2
X186 newdene_0/counnew_0/a_2268_16918# newdene_0/counnew_0/a_1888_16918# VDPWR VDPWR sky130_fd_pr__pfet_01v8 ad=0.75 pd=3.1 as=1.5 ps=6.2 w=2.5 l=0.2
X187 newdene_0/counnew_0/a_n5712_16918# uo_out[7] newdene_0/counnew_0/a_n5872_16918# VDPWR sky130_fd_pr__pfet_01v8 ad=1.5 pd=6.2 as=0.75 ps=3.1 w=2.5 l=0.2
X188 newdene_0/counnew_0/a_88_12918# newdene_0/AND_0/out newdene_0/counnew_0/a_n92_12918# newdene_0/counnew_0/gnd sky130_fd_pr__nfet_01v8 ad=0.3 pd=1.6 as=0.3 ps=1.6 w=1 l=0.3
X189 newdene_0/counnew_0/a_n1492_14878# uo_out[5] newdene_0/counnew_0/gnd newdene_0/counnew_0/gnd sky130_fd_pr__nfet_01v8 ad=0.3 pd=1.6 as=0.6 ps=3.2 w=1 l=0.3
X190 VDPWR newdene_0/counnew_0/a_7168_16878# newdene_0/counnew_0/a_7048_16918# VDPWR sky130_fd_pr__pfet_01v8 ad=1.5 pd=6.2 as=0.75 ps=3.1 w=2.5 l=0.2
X191 VDPWR newdene_0/counnew_0/a_n3992_16918# newdene_0/counnew_0/a_n4292_15878# VDPWR sky130_fd_pr__pfet_01v8 ad=0.45 pd=2.1 as=0.45 ps=2.1 w=1.5 l=0.3
X192 newdene_0/counnew_0/a_2768_17818# newdene_0/counnew_0/a_1888_16918# newdene_0/counnew_0/a_2428_16918# newdene_0/counnew_0/gnd sky130_fd_pr__nfet_01v8 ad=0.3 pd=1.6 as=0.6 ps=3.2 w=1 l=0.2
X193 newdene_0/counnew_0/a_n4472_13338# newdene_0/counnew_0/a_n4472_14578# VDPWR VDPWR sky130_fd_pr__pfet_01v8 ad=0.45 pd=2.1 as=0.9 ps=4.2 w=1.5 l=0.3
X194 newdene_0/counnew_0/a_6228_14578# newdene_0/counnew_0/a_6228_13338# VDPWR VDPWR sky130_fd_pr__pfet_01v8 ad=0.9 pd=4.2 as=0.45 ps=2.1 w=1.5 l=0.3
X195 uo_out[3] VDPWR VDPWR VDPWR sky130_fd_pr__pfet_01v8 ad=0.45 pd=2.1 as=0.9 ps=4.2 w=1.5 l=0.3
X196 newdene_0/counnew_0/a_8688_16918# newdene_0/counnew_0/a_8308_16918# VDPWR VDPWR sky130_fd_pr__pfet_01v8 ad=0.75 pd=3.1 as=1.5 ps=6.2 w=2.5 l=0.2
X197 newdene_0/counnew_0/a_n4372_15558# VDPWR newdene_0/counnew_0/gnd newdene_0/counnew_0/gnd sky130_fd_pr__nfet_01v8 ad=0.3 pd=1.6 as=0.6 ps=3.2 w=1 l=0.3
X198 newdene_0/counnew_0/a_n2332_14578# VDPWR VDPWR VDPWR sky130_fd_pr__pfet_01v8 ad=0.45 pd=2.1 as=0.9 ps=4.2 w=1.5 l=0.3
X199 newdene_0/counnew_0/a_7048_17818# newdene_0/counnew_0/a_6168_16918# newdene_0/counnew_0/a_6708_16918# newdene_0/counnew_0/gnd sky130_fd_pr__nfet_01v8 ad=0.3 pd=1.6 as=0.6 ps=3.2 w=1 l=0.2
X200 newdene_0/counnew_0/a_n3232_18858# uo_out[7] VDPWR VDPWR sky130_fd_pr__pfet_01v8 ad=0.36 pd=1.8 as=0.72 ps=3.6 w=1.2 l=0.2
X201 uo_out[1] VDPWR VDPWR VDPWR sky130_fd_pr__pfet_01v8 ad=0.45 pd=2.1 as=0.9 ps=4.2 w=1.5 l=0.3
X202 newdene_0/counnew_0/a_n1852_16918# uo_out[5] newdene_0/counnew_0/a_n2012_16918# VDPWR sky130_fd_pr__pfet_01v8 ad=1.5 pd=6.2 as=0.75 ps=3.1 w=2.5 l=0.2
X203 newdene_0/counnew_0/a_828_12918# newdene_0/counnew_0/a_288_16918# newdene_0/counnew_0/a_648_12918# newdene_0/counnew_0/gnd sky130_fd_pr__nfet_01v8 ad=0.3 pd=1.6 as=0.3 ps=1.6 w=1 l=0.3
X204 newdene_0/counnew_0/a_2128_15878# rst_n newdene_0/counnew_0/a_2968_12918# newdene_0/counnew_0/gnd sky130_fd_pr__nfet_01v8 ad=0.6 pd=3.2 as=0.3 ps=1.6 w=1 l=0.3
X205 newdene_0/counnew_0/a_n192_14578# VDPWR VDPWR VDPWR sky130_fd_pr__pfet_01v8 ad=0.45 pd=2.1 as=0.9 ps=4.2 w=1.5 l=0.3
X206 newdene_0/counnew_0/a_6708_16918# newdene_0/counnew_0/a_5648_18858# newdene_0/counnew_0/a_6548_17818# newdene_0/counnew_0/gnd sky130_fd_pr__nfet_01v8 ad=0.6 pd=3.2 as=0.3 ps=1.6 w=1 l=0.2
X207 newdene_0/counnew_0/a_4088_13338# rst_n newdene_0/counnew_0/a_4368_14878# newdene_0/counnew_0/gnd sky130_fd_pr__nfet_01v8 ad=0.6 pd=3.2 as=0.3 ps=1.6 w=1 l=0.3
X208 VDPWR newdene_0/AND_0/out newdene_0/counnew_0/a_6328_13478# VDPWR sky130_fd_pr__pfet_01v8 ad=0.45 pd=2.1 as=0.45 ps=2.1 w=1.5 l=0.3
X209 newdene_0/counnew_0/a_n6012_15878# newdene_0/counnew_0/a_n6092_13478# VDPWR VDPWR sky130_fd_pr__pfet_01v8 ad=0.45 pd=2.1 as=0.9 ps=4.2 w=1.5 l=0.3
X210 newdene_0/counnew_0/a_7068_14218# rst_n VDPWR VDPWR sky130_fd_pr__pfet_01v8 ad=0.9 pd=4.2 as=0.45 ps=2.1 w=1.5 l=0.3
X211 VDPWR newdene_0/counnew_0/a_n2152_15878# newdene_0/counnew_0/a_n2332_14578# VDPWR sky130_fd_pr__pfet_01v8 ad=0.45 pd=2.1 as=0.45 ps=2.1 w=1.5 l=0.3
X212 newdene_0/counnew_0/a_1368_18858# newdene_0/counnew_0/a_1048_18858# newdene_0/counnew_0/gnd newdene_0/counnew_0/gnd sky130_fd_pr__nfet_01v8 ad=0.42 pd=2.6 as=0.42 ps=2.6 w=0.7 l=0.2
X213 uo_out[1] newdene_0/counnew_0/a_7068_14218# newdene_0/counnew_0/a_7248_15558# newdene_0/counnew_0/gnd sky130_fd_pr__nfet_01v8 ad=0.6 pd=3.2 as=0.3 ps=1.6 w=1 l=0.3
X214 newdene_0/counnew_0/a_5648_18858# newdene_0/counnew_0/a_5328_18858# VDPWR VDPWR sky130_fd_pr__pfet_01v8 ad=0.72 pd=3.6 as=0.36 ps=1.8 w=1.2 l=0.2
X215 newdene_0/counnew_0/a_n5912_14878# newdene_0/AND_0/out newdene_0/counnew_0/a_n6092_14878# newdene_0/counnew_0/gnd sky130_fd_pr__nfet_01v8 ad=0.3 pd=1.6 as=0.3 ps=1.6 w=1 l=0.3
X216 newdene_0/counnew_0/a_n4152_17818# uo_out[6] newdene_0/counnew_0/gnd newdene_0/counnew_0/gnd sky130_fd_pr__nfet_01v8 ad=0.3 pd=1.6 as=0.6 ps=3.2 w=1 l=0.2
X217 newdene_0/counnew_0/a_n192_14578# newdene_0/counnew_0/a_n192_13338# VDPWR VDPWR sky130_fd_pr__pfet_01v8 ad=0.9 pd=4.2 as=0.45 ps=2.1 w=1.5 l=0.3
X218 newdene_0/counnew_0/a_7788_18858# newdene_0/counnew_0/a_7468_18858# newdene_0/counnew_0/gnd newdene_0/counnew_0/gnd sky130_fd_pr__nfet_01v8 ad=0.42 pd=2.6 as=0.42 ps=2.6 w=0.7 l=0.2
X219 newdene_0/counnew_0/a_n2152_15878# newdene_0/counnew_0/a_n2232_13478# VDPWR VDPWR sky130_fd_pr__pfet_01v8 ad=0.45 pd=2.1 as=0.9 ps=4.2 w=1.5 l=0.3
X220 VDPWR newdene_0/counnew_0/a_2048_13478# newdene_0/counnew_0/a_2788_14218# VDPWR sky130_fd_pr__pfet_01v8 ad=0.45 pd=2.1 as=0.45 ps=2.1 w=1.5 l=0.3
X221 newdene_0/counnew_0/a_4368_14878# newdene_0/AND_0/out newdene_0/counnew_0/a_4188_14878# newdene_0/counnew_0/gnd sky130_fd_pr__nfet_01v8 ad=0.3 pd=1.6 as=0.3 ps=1.6 w=1 l=0.3
X222 newdene_0/counnew_0/a_2968_15558# newdene_0/counnew_0/a_1948_13338# newdene_0/counnew_0/a_2788_15558# newdene_0/counnew_0/gnd sky130_fd_pr__nfet_01v8 ad=0.3 pd=1.6 as=0.3 ps=1.6 w=1 l=0.3
X223 newdene_0/counnew_0/gnd uo_out[6] newdene_0/counnew_0/a_n3532_16878# newdene_0/counnew_0/gnd sky130_fd_pr__nfet_01v8 ad=0.6 pd=3.2 as=0.6 ps=3.2 w=1 l=0.2
X224 newdene_0/counnew_0/a_9388_12918# newdene_0/counnew_0/a_8848_16918# newdene_0/counnew_0/a_9208_12918# newdene_0/counnew_0/gnd sky130_fd_pr__nfet_01v8 ad=0.3 pd=1.6 as=0.3 ps=1.6 w=1 l=0.3
X225 newdene_0/counnew_0/a_5328_18858# uo_out[2] newdene_0/counnew_0/a_5328_18478# newdene_0/counnew_0/gnd sky130_fd_pr__nfet_01v8 ad=0.42 pd=2.6 as=0.21 ps=1.3 w=0.7 l=0.2
X226 VDPWR newdene_0/counnew_0/a_4088_13338# uo_out[2] VDPWR sky130_fd_pr__pfet_01v8 ad=0.45 pd=2.1 as=0.45 ps=2.1 w=1.5 l=0.3
X227 VDPWR uo_out[1] newdene_0/counnew_0/a_7168_16878# VDPWR sky130_fd_pr__pfet_01v8 ad=1.5 pd=6.2 as=1.5 ps=6.2 w=2.5 l=0.2
X228 newdene_0/counnew_0/a_288_16918# newdene_0/counnew_0/a_n772_18858# newdene_0/counnew_0/a_128_17818# newdene_0/counnew_0/gnd sky130_fd_pr__nfet_01v8 ad=0.6 pd=3.2 as=0.3 ps=1.6 w=1 l=0.2
X229 uo_out[7] newdene_0/counnew_0/a_n5352_14218# VDPWR VDPWR sky130_fd_pr__pfet_01v8 ad=0.9 pd=4.2 as=0.45 ps=2.1 w=1.5 l=0.3
X230 VDPWR newdene_0/counnew_0/a_5028_16878# newdene_0/counnew_0/a_4908_16918# VDPWR sky130_fd_pr__pfet_01v8 ad=1.5 pd=6.2 as=0.75 ps=3.1 w=2.5 l=0.2
X231 newdene_0/counnew_0/a_n4372_12918# newdene_0/counnew_0/a_n4472_13338# newdene_0/counnew_0/gnd newdene_0/counnew_0/gnd sky130_fd_pr__nfet_01v8 ad=0.3 pd=1.6 as=0.6 ps=3.2 w=1 l=0.3
X232 newdene_0/counnew_0/a_4188_13478# newdene_0/counnew_0/a_4268_15878# VDPWR VDPWR sky130_fd_pr__pfet_01v8 ad=0.9 pd=4.2 as=0.45 ps=2.1 w=1.5 l=0.3
X233 newdene_0/counnew_0/a_648_14878# uo_out[4] newdene_0/counnew_0/gnd newdene_0/counnew_0/gnd sky130_fd_pr__nfet_01v8 ad=0.3 pd=1.6 as=0.6 ps=3.2 w=1 l=0.3
X234 newdene_0/counnew_0/a_6548_16918# newdene_0/counnew_0/a_6168_16918# VDPWR VDPWR sky130_fd_pr__pfet_01v8 ad=0.75 pd=3.1 as=1.5 ps=6.2 w=2.5 l=0.2
X235 newdene_0/counnew_0/a_n3632_14218# rst_n VDPWR VDPWR sky130_fd_pr__pfet_01v8 ad=0.9 pd=4.2 as=0.45 ps=2.1 w=1.5 l=0.3
X236 newdene_0/counnew_0/a_n2332_13338# rst_n newdene_0/counnew_0/a_n2052_14878# newdene_0/counnew_0/gnd sky130_fd_pr__nfet_01v8 ad=0.6 pd=3.2 as=0.3 ps=1.6 w=1 l=0.3
X237 uo_out[6] newdene_0/counnew_0/a_n3632_14218# newdene_0/counnew_0/a_n3452_15558# newdene_0/counnew_0/gnd sky130_fd_pr__nfet_01v8 ad=0.6 pd=3.2 as=0.3 ps=1.6 w=1 l=0.3
X238 newdene_0/counnew_0/a_n1092_18858# newdene_0/counnew_0/a_n2912_18858# VDPWR VDPWR sky130_fd_pr__pfet_01v8 ad=0.36 pd=1.8 as=0.72 ps=3.6 w=1.2 l=0.2
X239 uo_out[5] newdene_0/counnew_0/a_n1492_14218# VDPWR VDPWR sky130_fd_pr__pfet_01v8 ad=0.9 pd=4.2 as=0.45 ps=2.1 w=1.5 l=0.3
X240 VDPWR newdene_0/counnew_0/a_n12_15878# newdene_0/counnew_0/a_n192_14578# VDPWR sky130_fd_pr__pfet_01v8 ad=0.45 pd=2.1 as=0.45 ps=2.1 w=1.5 l=0.3
X241 VDPWR newdene_0/AND_0/out newdene_0/counnew_0/a_n6092_13478# VDPWR sky130_fd_pr__pfet_01v8 ad=0.45 pd=2.1 as=0.45 ps=2.1 w=1.5 l=0.3
X242 newdene_0/counnew_0/a_n3992_16918# uo_out[6] newdene_0/counnew_0/a_n4152_16918# VDPWR sky130_fd_pr__pfet_01v8 ad=1.5 pd=6.2 as=0.75 ps=3.1 w=2.5 l=0.2
X243 newdene_0/counnew_0/a_4568_16918# newdene_0/counnew_0/a_3508_18858# newdene_0/counnew_0/a_4408_17818# newdene_0/counnew_0/gnd sky130_fd_pr__nfet_01v8 ad=0.6 pd=3.2 as=0.3 ps=1.6 w=1 l=0.2
X244 VDPWR uo_out[4] newdene_0/counnew_0/a_1048_18858# VDPWR sky130_fd_pr__pfet_01v8 ad=0.36 pd=1.8 as=0.36 ps=1.8 w=1.2 l=0.2
X245 newdene_0/counnew_0/a_1948_13338# rst_n newdene_0/counnew_0/a_2228_14878# newdene_0/counnew_0/gnd sky130_fd_pr__nfet_01v8 ad=0.6 pd=3.2 as=0.3 ps=1.6 w=1 l=0.3
X246 VDPWR newdene_0/AND_0/out newdene_0/counnew_0/a_4188_13478# VDPWR sky130_fd_pr__pfet_01v8 ad=0.45 pd=2.1 as=0.45 ps=2.1 w=1.5 l=0.3
X247 newdene_0/counnew_0/a_1948_13338# newdene_0/counnew_0/a_1948_14578# VDPWR VDPWR sky130_fd_pr__pfet_01v8 ad=0.45 pd=2.1 as=0.9 ps=4.2 w=1.5 l=0.3
X248 newdene_0/counnew_0/a_6408_15878# rst_n newdene_0/counnew_0/a_7248_12918# newdene_0/counnew_0/gnd sky130_fd_pr__nfet_01v8 ad=0.6 pd=3.2 as=0.3 ps=1.6 w=1 l=0.3
X249 VDPWR newdene_0/counnew_0/a_n192_13338# uo_out[4] VDPWR sky130_fd_pr__pfet_01v8 ad=0.45 pd=2.1 as=0.45 ps=2.1 w=1.5 l=0.3
X250 newdene_0/counnew_0/a_4928_14218# rst_n VDPWR VDPWR sky130_fd_pr__pfet_01v8 ad=0.9 pd=4.2 as=0.45 ps=2.1 w=1.5 l=0.3
X251 newdene_0/counnew_0/a_2048_15558# VDPWR newdene_0/counnew_0/gnd newdene_0/counnew_0/gnd sky130_fd_pr__nfet_01v8 ad=0.3 pd=1.6 as=0.6 ps=3.2 w=1 l=0.3
X252 newdene_0/counnew_0/a_n3652_16918# uo_out[7] newdene_0/counnew_0/a_n3992_16918# VDPWR sky130_fd_pr__pfet_01v8 ad=0.75 pd=3.1 as=1.5 ps=6.2 w=2.5 l=0.2
X253 VDPWR uo_out[1] newdene_0/counnew_0/a_7468_18858# VDPWR sky130_fd_pr__pfet_01v8 ad=0.36 pd=1.8 as=0.36 ps=1.8 w=1.2 l=0.2
X254 newdene_0/counnew_0/a_6228_13338# newdene_0/counnew_0/a_6228_14578# VDPWR VDPWR sky130_fd_pr__pfet_01v8 ad=0.45 pd=2.1 as=0.9 ps=4.2 w=1.5 l=0.3
X255 uo_out[2] newdene_0/counnew_0/a_4928_14218# newdene_0/counnew_0/a_5108_15558# newdene_0/counnew_0/gnd sky130_fd_pr__nfet_01v8 ad=0.6 pd=3.2 as=0.3 ps=1.6 w=1 l=0.3
X256 newdene_0/counnew_0/a_4928_14878# uo_out[2] newdene_0/counnew_0/gnd newdene_0/counnew_0/gnd sky130_fd_pr__nfet_01v8 ad=0.3 pd=1.6 as=0.6 ps=3.2 w=1 l=0.3
X257 uo_out[3] newdene_0/counnew_0/a_2788_14218# VDPWR VDPWR sky130_fd_pr__pfet_01v8 ad=0.9 pd=4.2 as=0.45 ps=2.1 w=1.5 l=0.3
X258 VDPWR newdene_0/counnew_0/a_n6092_13478# newdene_0/counnew_0/a_n5352_14218# VDPWR sky130_fd_pr__pfet_01v8 ad=0.45 pd=2.1 as=0.45 ps=2.1 w=1.5 l=0.3
X259 newdene_0/counnew_0/a_8368_13338# rst_n newdene_0/counnew_0/a_8648_14878# newdene_0/counnew_0/gnd sky130_fd_pr__nfet_01v8 ad=0.6 pd=3.2 as=0.3 ps=1.6 w=1 l=0.3
X260 newdene_0/counnew_0/a_n2012_17818# uo_out[5] newdene_0/counnew_0/gnd newdene_0/counnew_0/gnd sky130_fd_pr__nfet_01v8 ad=0.3 pd=1.6 as=0.6 ps=3.2 w=1 l=0.2
X261 newdene_0/counnew_0/a_6328_15558# VDPWR newdene_0/counnew_0/gnd newdene_0/counnew_0/gnd sky130_fd_pr__nfet_01v8 ad=0.3 pd=1.6 as=0.6 ps=3.2 w=1 l=0.3
X262 newdene_0/counnew_0/a_n5172_15558# newdene_0/counnew_0/a_n6192_13338# newdene_0/counnew_0/a_n5352_15558# newdene_0/counnew_0/gnd sky130_fd_pr__nfet_01v8 ad=0.3 pd=1.6 as=0.3 ps=1.6 w=1 l=0.3
X263 newdene_0/counnew_0/a_n1092_18858# uo_out[5] newdene_0/counnew_0/a_n1092_18478# newdene_0/counnew_0/gnd sky130_fd_pr__nfet_01v8 ad=0.42 pd=2.6 as=0.21 ps=1.3 w=0.7 l=0.2
X264 newdene_0/counnew_0/a_9208_14878# uo_out[0] newdene_0/counnew_0/gnd newdene_0/counnew_0/gnd sky130_fd_pr__nfet_01v8 ad=0.3 pd=1.6 as=0.6 ps=3.2 w=1 l=0.3
X265 VDPWR newdene_0/counnew_0/a_748_16878# newdene_0/counnew_0/a_628_16918# VDPWR sky130_fd_pr__pfet_01v8 ad=1.5 pd=6.2 as=0.75 ps=3.1 w=2.5 l=0.2
X266 newdene_0/counnew_0/gnd newdene_0/counnew_0/a_n3532_16878# newdene_0/counnew_0/a_n3652_17818# newdene_0/counnew_0/gnd sky130_fd_pr__nfet_01v8 ad=0.6 pd=3.2 as=0.3 ps=1.6 w=1 l=0.2
X267 newdene_0/counnew_0/a_2968_12918# newdene_0/counnew_0/a_2428_16918# newdene_0/counnew_0/a_2788_12918# newdene_0/counnew_0/gnd sky130_fd_pr__nfet_01v8 ad=0.3 pd=1.6 as=0.3 ps=1.6 w=1 l=0.3
X268 newdene_0/counnew_0/a_n4532_16918# uo_out[7] newdene_0/counnew_0/gnd newdene_0/counnew_0/gnd sky130_fd_pr__nfet_01v8 ad=0.6 pd=3.2 as=0.6 ps=3.2 w=1 l=0.2
X269 newdene_0/counnew_0/gnd uo_out[5] newdene_0/counnew_0/a_n1392_16878# newdene_0/counnew_0/gnd sky130_fd_pr__nfet_01v8 ad=0.6 pd=3.2 as=0.6 ps=3.2 w=1 l=0.2
X270 newdene_0/counnew_0/a_3188_18858# uo_out[3] newdene_0/counnew_0/a_3188_18478# newdene_0/counnew_0/gnd sky130_fd_pr__nfet_01v8 ad=0.42 pd=2.6 as=0.21 ps=1.3 w=0.7 l=0.2
X271 newdene_0/counnew_0/a_n12_15878# newdene_0/counnew_0/a_n92_13478# VDPWR VDPWR sky130_fd_pr__pfet_01v8 ad=0.45 pd=2.1 as=0.9 ps=4.2 w=1.5 l=0.3
X272 VDPWR newdene_0/counnew_0/a_n2232_13478# newdene_0/counnew_0/a_n1492_14218# VDPWR sky130_fd_pr__pfet_01v8 ad=0.45 pd=2.1 as=0.45 ps=2.1 w=1.5 l=0.3
X273 newdene_0/counnew_0/a_n2232_13478# newdene_0/counnew_0/a_n2152_15878# VDPWR VDPWR sky130_fd_pr__pfet_01v8 ad=0.9 pd=4.2 as=0.45 ps=2.1 w=1.5 l=0.3
X274 newdene_0/counnew_0/a_n1312_15558# newdene_0/counnew_0/a_n2332_13338# newdene_0/counnew_0/a_n1492_15558# newdene_0/counnew_0/gnd sky130_fd_pr__nfet_01v8 ad=0.3 pd=1.6 as=0.3 ps=1.6 w=1 l=0.3
X275 newdene_0/counnew_0/a_n4192_14878# newdene_0/AND_0/out newdene_0/counnew_0/a_n4372_14878# newdene_0/counnew_0/gnd sky130_fd_pr__nfet_01v8 ad=0.3 pd=1.6 as=0.3 ps=1.6 w=1 l=0.3
X276 newdene_0/counnew_0/a_128_16918# newdene_0/counnew_0/a_n252_16918# VDPWR VDPWR sky130_fd_pr__pfet_01v8 ad=0.75 pd=3.1 as=1.5 ps=6.2 w=2.5 l=0.2
X277 newdene_0/counnew_0/gnd uo_out[4] newdene_0/counnew_0/a_748_16878# newdene_0/counnew_0/gnd sky130_fd_pr__nfet_01v8 ad=0.6 pd=3.2 as=0.6 ps=3.2 w=1 l=0.2
X278 VDPWR newdene_0/counnew_0/a_8368_13338# uo_out[0] VDPWR sky130_fd_pr__pfet_01v8 ad=0.45 pd=2.1 as=0.45 ps=2.1 w=1.5 l=0.3
X279 newdene_0/counnew_0/a_648_14218# rst_n VDPWR VDPWR sky130_fd_pr__pfet_01v8 ad=0.9 pd=4.2 as=0.45 ps=2.1 w=1.5 l=0.3
X280 newdene_0/counnew_0/a_2048_13478# newdene_0/counnew_0/a_2128_15878# VDPWR VDPWR sky130_fd_pr__pfet_01v8 ad=0.9 pd=4.2 as=0.45 ps=2.1 w=1.5 l=0.3
X281 newdene_0/counnew_0/a_n4292_15878# rst_n newdene_0/counnew_0/a_n3452_12918# newdene_0/counnew_0/gnd sky130_fd_pr__nfet_01v8 ad=0.6 pd=3.2 as=0.3 ps=1.6 w=1 l=0.3
X282 uo_out[4] newdene_0/counnew_0/a_648_14218# newdene_0/counnew_0/a_828_15558# newdene_0/counnew_0/gnd sky130_fd_pr__nfet_01v8 ad=0.6 pd=3.2 as=0.3 ps=1.6 w=1 l=0.3
X283 VDPWR newdene_0/counnew_0/a_9308_16878# newdene_0/counnew_0/a_9188_16918# VDPWR sky130_fd_pr__pfet_01v8 ad=1.5 pd=6.2 as=0.75 ps=3.1 w=2.5 l=0.2
X284 newdene_0/counnew_0/a_4268_15878# newdene_0/counnew_0/a_4188_13478# VDPWR VDPWR sky130_fd_pr__pfet_01v8 ad=0.45 pd=2.1 as=0.9 ps=4.2 w=1.5 l=0.3
X285 newdene_0/counnew_0/a_8468_13478# newdene_0/counnew_0/a_8548_15878# VDPWR VDPWR sky130_fd_pr__pfet_01v8 ad=0.9 pd=4.2 as=0.45 ps=2.1 w=1.5 l=0.3
X286 newdene_0/counnew_0/a_n5372_16918# VDPWR newdene_0/counnew_0/a_n5712_16918# VDPWR sky130_fd_pr__pfet_01v8 ad=0.75 pd=3.1 as=1.5 ps=6.2 w=2.5 l=0.2
X287 newdene_0/counnew_0/a_n4472_14578# VDPWR VDPWR VDPWR sky130_fd_pr__pfet_01v8 ad=0.45 pd=2.1 as=0.9 ps=4.2 w=1.5 l=0.3
X288 newdene_0/counnew_0/a_7248_14878# newdene_0/counnew_0/a_6328_13478# newdene_0/counnew_0/a_7068_14878# newdene_0/counnew_0/gnd sky130_fd_pr__nfet_01v8 ad=0.3 pd=1.6 as=0.3 ps=1.6 w=1 l=0.3
X289 newdene_0/counnew_0/a_8548_15878# newdene_0/counnew_0/a_8468_13478# VDPWR VDPWR sky130_fd_pr__pfet_01v8 ad=0.45 pd=2.1 as=0.9 ps=4.2 w=1.5 l=0.3
X290 newdene_0/counnew_0/a_n6092_14878# newdene_0/counnew_0/a_n6192_14578# newdene_0/counnew_0/gnd newdene_0/counnew_0/gnd sky130_fd_pr__nfet_01v8 ad=0.3 pd=1.6 as=0.6 ps=3.2 w=1 l=0.3
X291 newdene_0/counnew_0/a_n5872_17818# uo_out[7] newdene_0/counnew_0/gnd newdene_0/counnew_0/gnd sky130_fd_pr__nfet_01v8 ad=0.3 pd=1.6 as=0.6 ps=3.2 w=1 l=0.2
X292 newdene_0/counnew_0/a_n6192_13338# rst_n VDPWR VDPWR sky130_fd_pr__pfet_01v8 ad=0.9 pd=4.2 as=0.45 ps=2.1 w=1.5 l=0.3
X293 newdene_0/counnew_0/a_2048_12918# newdene_0/counnew_0/a_1948_13338# newdene_0/counnew_0/gnd newdene_0/counnew_0/gnd sky130_fd_pr__nfet_01v8 ad=0.3 pd=1.6 as=0.6 ps=3.2 w=1 l=0.3
X294 newdene_0/counnew_0/a_n6192_14578# newdene_0/counnew_0/a_n6192_13338# newdene_0/counnew_0/a_n5912_15558# newdene_0/counnew_0/gnd sky130_fd_pr__nfet_01v8 ad=0.6 pd=3.2 as=0.3 ps=1.6 w=1 l=0.3
X295 newdene_0/counnew_0/a_4268_15878# rst_n newdene_0/counnew_0/a_5108_12918# newdene_0/counnew_0/gnd sky130_fd_pr__nfet_01v8 ad=0.6 pd=3.2 as=0.3 ps=1.6 w=1 l=0.3
X296 newdene_0/counnew_0/a_n1512_16918# newdene_0/counnew_0/a_n2912_18858# newdene_0/counnew_0/a_n1852_16918# VDPWR sky130_fd_pr__pfet_01v8 ad=0.75 pd=3.1 as=1.5 ps=6.2 w=2.5 l=0.2
X297 newdene_0/counnew_0/a_8848_16918# newdene_0/counnew_0/a_7788_18858# newdene_0/counnew_0/a_8688_17818# newdene_0/counnew_0/gnd sky130_fd_pr__nfet_01v8 ad=0.6 pd=3.2 as=0.3 ps=1.6 w=1 l=0.2
X298 VDPWR uo_out[2] newdene_0/counnew_0/a_5328_18858# VDPWR sky130_fd_pr__pfet_01v8 ad=0.36 pd=1.8 as=0.36 ps=1.8 w=1.2 l=0.2
X299 newdene_0/counnew_0/a_6328_12918# newdene_0/counnew_0/a_6228_13338# newdene_0/counnew_0/gnd newdene_0/counnew_0/gnd sky130_fd_pr__nfet_01v8 ad=0.3 pd=1.6 as=0.6 ps=3.2 w=1 l=0.3
X300 newdene_0/counnew_0/a_n5172_12918# newdene_0/counnew_0/a_n5712_16918# newdene_0/counnew_0/a_n5352_12918# newdene_0/counnew_0/gnd sky130_fd_pr__nfet_01v8 ad=0.3 pd=1.6 as=0.3 ps=1.6 w=1 l=0.3
X301 newdene_0/counnew_0/a_4088_13338# newdene_0/counnew_0/a_4088_14578# VDPWR VDPWR sky130_fd_pr__pfet_01v8 ad=0.45 pd=2.1 as=0.9 ps=4.2 w=1.5 l=0.3
X302 newdene_0/counnew_0/a_2788_14878# uo_out[3] newdene_0/counnew_0/gnd newdene_0/counnew_0/gnd sky130_fd_pr__nfet_01v8 ad=0.3 pd=1.6 as=0.6 ps=3.2 w=1 l=0.3
X303 newdene_0/counnew_0/a_6228_13338# rst_n newdene_0/counnew_0/a_6508_14878# newdene_0/counnew_0/gnd sky130_fd_pr__nfet_01v8 ad=0.6 pd=3.2 as=0.3 ps=1.6 w=1 l=0.3
X304 newdene_0/counnew_0/gnd uo_out[7] newdene_0/counnew_0/a_n5252_16878# newdene_0/counnew_0/gnd sky130_fd_pr__nfet_01v8 ad=0.6 pd=3.2 as=0.6 ps=3.2 w=1 l=0.2
X305 newdene_0/counnew_0/a_4188_15558# VDPWR newdene_0/counnew_0/gnd newdene_0/counnew_0/gnd sky130_fd_pr__nfet_01v8 ad=0.3 pd=1.6 as=0.6 ps=3.2 w=1 l=0.3
X306 newdene_0/counnew_0/a_n2232_14878# newdene_0/counnew_0/a_n2332_14578# newdene_0/counnew_0/gnd newdene_0/counnew_0/gnd sky130_fd_pr__nfet_01v8 ad=0.3 pd=1.6 as=0.6 ps=3.2 w=1 l=0.3
X307 VDPWR newdene_0/AND_0/out newdene_0/counnew_0/a_n4372_13478# VDPWR sky130_fd_pr__pfet_01v8 ad=0.45 pd=2.1 as=0.45 ps=2.1 w=1.5 l=0.3
X308 newdene_0/counnew_0/a_9208_14218# rst_n VDPWR VDPWR sky130_fd_pr__pfet_01v8 ad=0.9 pd=4.2 as=0.45 ps=2.1 w=1.5 l=0.3
X309 newdene_0/counnew_0/a_7068_14878# uo_out[1] newdene_0/counnew_0/gnd newdene_0/counnew_0/gnd sky130_fd_pr__nfet_01v8 ad=0.3 pd=1.6 as=0.6 ps=3.2 w=1 l=0.3
X310 uo_out[0] newdene_0/counnew_0/a_9208_14218# newdene_0/counnew_0/a_9388_15558# newdene_0/counnew_0/gnd sky130_fd_pr__nfet_01v8 ad=0.6 pd=3.2 as=0.3 ps=1.6 w=1 l=0.3
X311 uo_out[1] newdene_0/counnew_0/a_7068_14218# VDPWR VDPWR sky130_fd_pr__pfet_01v8 ad=0.9 pd=4.2 as=0.45 ps=2.1 w=1.5 l=0.3
X312 newdene_0/counnew_0/a_n2392_16918# newdene_0/counnew_0/a_n2912_18858# newdene_0/counnew_0/gnd newdene_0/counnew_0/gnd sky130_fd_pr__nfet_01v8 ad=0.6 pd=3.2 as=0.6 ps=3.2 w=1 l=0.2
X313 newdene_0/counnew_0/a_5328_18478# newdene_0/counnew_0/a_3508_18858# newdene_0/counnew_0/gnd newdene_0/counnew_0/gnd sky130_fd_pr__nfet_01v8 ad=0.21 pd=1.3 as=0.42 ps=2.6 w=0.7 l=0.2
X314 newdene_0/counnew_0/a_n92_14878# newdene_0/counnew_0/a_n192_14578# newdene_0/counnew_0/gnd newdene_0/counnew_0/gnd sky130_fd_pr__nfet_01v8 ad=0.3 pd=1.6 as=0.6 ps=3.2 w=1 l=0.3
X315 newdene_0/counnew_0/a_n1312_12918# newdene_0/counnew_0/a_n1852_16918# newdene_0/counnew_0/a_n1492_12918# newdene_0/counnew_0/gnd sky130_fd_pr__nfet_01v8 ad=0.3 pd=1.6 as=0.3 ps=1.6 w=1 l=0.3
X316 VDPWR newdene_0/counnew_0/a_1948_13338# uo_out[3] VDPWR sky130_fd_pr__pfet_01v8 ad=0.45 pd=2.1 as=0.45 ps=2.1 w=1.5 l=0.3
X317 newdene_0/counnew_0/a_n2052_14878# newdene_0/AND_0/out newdene_0/counnew_0/a_n2232_14878# newdene_0/counnew_0/gnd sky130_fd_pr__nfet_01v8 ad=0.3 pd=1.6 as=0.3 ps=1.6 w=1 l=0.3
X318 VDPWR newdene_0/counnew_0/a_6708_16918# newdene_0/counnew_0/a_6408_15878# VDPWR sky130_fd_pr__pfet_01v8 ad=0.45 pd=2.1 as=0.45 ps=2.1 w=1.5 l=0.3
X319 newdene_0/counnew_0/a_n6092_13478# newdene_0/counnew_0/a_n6192_13338# VDPWR VDPWR sky130_fd_pr__pfet_01v8 ad=0.45 pd=2.1 as=0.9 ps=4.2 w=1.5 l=0.3
X320 newdene_0/counnew_0/a_n12_15878# rst_n newdene_0/counnew_0/a_828_12918# newdene_0/counnew_0/gnd sky130_fd_pr__nfet_01v8 ad=0.6 pd=3.2 as=0.3 ps=1.6 w=1 l=0.3
X321 newdene_0/counnew_0/gnd uo_out[2] newdene_0/counnew_0/a_5028_16878# newdene_0/counnew_0/gnd sky130_fd_pr__nfet_01v8 ad=0.6 pd=3.2 as=0.6 ps=3.2 w=1 l=0.2
X322 newdene_0/counnew_0/a_n192_13338# rst_n newdene_0/counnew_0/a_88_14878# newdene_0/counnew_0/gnd sky130_fd_pr__nfet_01v8 ad=0.6 pd=3.2 as=0.3 ps=1.6 w=1 l=0.3
X323 VDPWR newdene_0/AND_0/out newdene_0/counnew_0/a_1948_13338# VDPWR sky130_fd_pr__pfet_01v8 ad=0.45 pd=2.1 as=0.45 ps=2.1 w=1.5 l=0.3
X324 newdene_0/counnew_0/a_4028_16918# newdene_0/counnew_0/a_3508_18858# newdene_0/counnew_0/gnd newdene_0/counnew_0/gnd sky130_fd_pr__nfet_01v8 ad=0.6 pd=3.2 as=0.6 ps=3.2 w=1 l=0.2
X325 newdene_0/counnew_0/a_2128_15878# newdene_0/counnew_0/a_2048_13478# VDPWR VDPWR sky130_fd_pr__pfet_01v8 ad=0.45 pd=2.1 as=0.9 ps=4.2 w=1.5 l=0.3
X326 newdene_0/counnew_0/a_6328_13478# newdene_0/counnew_0/a_6408_15878# VDPWR VDPWR sky130_fd_pr__pfet_01v8 ad=0.9 pd=4.2 as=0.45 ps=2.1 w=1.5 l=0.3
X327 newdene_0/counnew_0/a_2228_15558# newdene_0/counnew_0/a_2128_15878# newdene_0/counnew_0/a_2048_15558# newdene_0/counnew_0/gnd sky130_fd_pr__nfet_01v8 ad=0.3 pd=1.6 as=0.3 ps=1.6 w=1 l=0.3
X328 newdene_0/counnew_0/a_n2232_13478# newdene_0/counnew_0/a_n2332_13338# VDPWR VDPWR sky130_fd_pr__pfet_01v8 ad=0.45 pd=2.1 as=0.9 ps=4.2 w=1.5 l=0.3
X329 newdene_0/counnew_0/a_8308_16918# newdene_0/counnew_0/a_7788_18858# newdene_0/counnew_0/gnd newdene_0/counnew_0/gnd sky130_fd_pr__nfet_01v8 ad=0.6 pd=3.2 as=0.6 ps=3.2 w=1 l=0.2
X330 newdene_0/counnew_0/a_4408_17818# uo_out[2] newdene_0/counnew_0/gnd newdene_0/counnew_0/gnd sky130_fd_pr__nfet_01v8 ad=0.3 pd=1.6 as=0.6 ps=3.2 w=1 l=0.2
X331 newdene_0/counnew_0/a_5108_14878# newdene_0/counnew_0/a_4188_13478# newdene_0/counnew_0/a_4928_14878# newdene_0/counnew_0/gnd sky130_fd_pr__nfet_01v8 ad=0.3 pd=1.6 as=0.3 ps=1.6 w=1 l=0.3
X332 newdene_0/counnew_0/a_6408_15878# newdene_0/counnew_0/a_6328_13478# VDPWR VDPWR sky130_fd_pr__pfet_01v8 ad=0.45 pd=2.1 as=0.9 ps=4.2 w=1.5 l=0.3
X333 uo_out[6] newdene_0/counnew_0/a_n3632_14218# VDPWR VDPWR sky130_fd_pr__pfet_01v8 ad=0.9 pd=4.2 as=0.45 ps=2.1 w=1.5 l=0.3
X334 VDPWR uo_out[5] newdene_0/counnew_0/a_n1092_18858# VDPWR sky130_fd_pr__pfet_01v8 ad=0.36 pd=1.8 as=0.36 ps=1.8 w=1.2 l=0.2
X335 newdene_0/counnew_0/a_n6092_13478# newdene_0/counnew_0/a_n6012_15878# newdene_0/counnew_0/a_n5912_12918# newdene_0/counnew_0/gnd sky130_fd_pr__nfet_01v8 ad=0.6 pd=3.2 as=0.3 ps=1.6 w=1 l=0.3
X336 VDPWR newdene_0/AND_0/out newdene_0/counnew_0/a_8368_13338# VDPWR sky130_fd_pr__pfet_01v8 ad=0.45 pd=2.1 as=0.45 ps=2.1 w=1.5 l=0.3
X337 newdene_0/counnew_0/a_n5352_14218# rst_n newdene_0/counnew_0/a_n5172_14878# newdene_0/counnew_0/gnd sky130_fd_pr__nfet_01v8 ad=0.6 pd=3.2 as=0.3 ps=1.6 w=1 l=0.3
X338 newdene_0/counnew_0/a_8648_15558# newdene_0/counnew_0/a_8548_15878# newdene_0/counnew_0/a_8468_15558# newdene_0/counnew_0/gnd sky130_fd_pr__nfet_01v8 ad=0.3 pd=1.6 as=0.3 ps=1.6 w=1 l=0.3
X339 newdene_0/counnew_0/a_n92_13478# newdene_0/counnew_0/a_n192_13338# VDPWR VDPWR sky130_fd_pr__pfet_01v8 ad=0.45 pd=2.1 as=0.9 ps=4.2 w=1.5 l=0.3
X340 VDPWR uo_out[3] newdene_0/counnew_0/a_3188_18858# VDPWR sky130_fd_pr__pfet_01v8 ad=0.36 pd=1.8 as=0.36 ps=1.8 w=1.2 l=0.2
X341 newdene_0/counnew_0/a_4188_12918# newdene_0/counnew_0/a_4088_13338# newdene_0/counnew_0/gnd newdene_0/counnew_0/gnd sky130_fd_pr__nfet_01v8 ad=0.3 pd=1.6 as=0.6 ps=3.2 w=1 l=0.3
X342 newdene_0/counnew_0/a_n3232_18858# uo_out[6] newdene_0/counnew_0/a_n3232_18478# newdene_0/counnew_0/gnd sky130_fd_pr__nfet_01v8 ad=0.42 pd=2.6 as=0.21 ps=1.3 w=0.7 l=0.2
X343 newdene_0/counnew_0/a_628_16918# newdene_0/counnew_0/a_n772_18858# newdene_0/counnew_0/a_288_16918# VDPWR sky130_fd_pr__pfet_01v8 ad=0.75 pd=3.1 as=1.5 ps=6.2 w=2.5 l=0.2
X344 newdene_0/counnew_0/a_8548_15878# rst_n newdene_0/counnew_0/a_9388_12918# newdene_0/counnew_0/gnd sky130_fd_pr__nfet_01v8 ad=0.6 pd=3.2 as=0.3 ps=1.6 w=1 l=0.3
X345 VDPWR newdene_0/AND_0/out newdene_0/counnew_0/a_n2232_13478# VDPWR sky130_fd_pr__pfet_01v8 ad=0.45 pd=2.1 as=0.45 ps=2.1 w=1.5 l=0.3
X346 newdene_0/counnew_0/a_n3632_14218# uo_out[6] VDPWR VDPWR sky130_fd_pr__pfet_01v8 ad=0.45 pd=2.1 as=0.9 ps=4.2 w=1.5 l=0.3
X347 newdene_0/counnew_0/a_n1492_14218# rst_n newdene_0/counnew_0/a_n1312_14878# newdene_0/counnew_0/gnd sky130_fd_pr__nfet_01v8 ad=0.6 pd=3.2 as=0.3 ps=1.6 w=1 l=0.3
X348 newdene_0/counnew_0/a_1948_14578# VDPWR VDPWR VDPWR sky130_fd_pr__pfet_01v8 ad=0.45 pd=2.1 as=0.9 ps=4.2 w=1.5 l=0.3
X349 newdene_0/counnew_0/a_8368_13338# newdene_0/counnew_0/a_8368_14578# VDPWR VDPWR sky130_fd_pr__pfet_01v8 ad=0.45 pd=2.1 as=0.9 ps=4.2 w=1.5 l=0.3
X350 newdene_0/counnew_0/a_n3632_15558# VDPWR newdene_0/counnew_0/gnd newdene_0/counnew_0/gnd sky130_fd_pr__nfet_01v8 ad=0.3 pd=1.6 as=0.6 ps=3.2 w=1 l=0.3
X351 uo_out[2] newdene_0/counnew_0/a_4928_14218# VDPWR VDPWR sky130_fd_pr__pfet_01v8 ad=0.9 pd=4.2 as=0.45 ps=2.1 w=1.5 l=0.3
X352 newdene_0/counnew_0/a_88_14878# newdene_0/AND_0/out newdene_0/counnew_0/a_n92_14878# newdene_0/counnew_0/gnd sky130_fd_pr__nfet_01v8 ad=0.3 pd=1.6 as=0.3 ps=1.6 w=1 l=0.3
X353 newdene_0/counnew_0/a_n4472_13338# rst_n VDPWR VDPWR sky130_fd_pr__pfet_01v8 ad=0.9 pd=4.2 as=0.45 ps=2.1 w=1.5 l=0.3
X354 newdene_0/counnew_0/a_n2912_18858# newdene_0/counnew_0/a_n3232_18858# newdene_0/counnew_0/gnd newdene_0/counnew_0/gnd sky130_fd_pr__nfet_01v8 ad=0.42 pd=2.6 as=0.42 ps=2.6 w=0.7 l=0.2
X355 newdene_0/counnew_0/a_3188_18478# newdene_0/counnew_0/a_1368_18858# newdene_0/counnew_0/gnd newdene_0/counnew_0/gnd sky130_fd_pr__nfet_01v8 ad=0.21 pd=1.3 as=0.42 ps=2.6 w=0.7 l=0.2
X356 newdene_0/counnew_0/a_8468_15558# VDPWR newdene_0/counnew_0/gnd newdene_0/counnew_0/gnd sky130_fd_pr__nfet_01v8 ad=0.3 pd=1.6 as=0.6 ps=3.2 w=1 l=0.3
X357 newdene_0/counnew_0/a_6228_14578# VDPWR VDPWR VDPWR sky130_fd_pr__pfet_01v8 ad=0.45 pd=2.1 as=0.9 ps=4.2 w=1.5 l=0.3
X358 newdene_0/counnew_0/a_n4472_14578# newdene_0/counnew_0/a_n4472_13338# newdene_0/counnew_0/a_n4192_15558# newdene_0/counnew_0/gnd sky130_fd_pr__nfet_01v8 ad=0.6 pd=3.2 as=0.3 ps=1.6 w=1 l=0.3
X359 VDPWR newdene_0/counnew_0/a_n6192_13338# uo_out[7] VDPWR sky130_fd_pr__pfet_01v8 ad=0.45 pd=2.1 as=0.45 ps=2.1 w=1.5 l=0.3
X360 newdene_0/counnew_0/a_n92_13478# newdene_0/counnew_0/a_n12_15878# VDPWR VDPWR sky130_fd_pr__pfet_01v8 ad=0.9 pd=4.2 as=0.45 ps=2.1 w=1.5 l=0.3
X361 newdene_0/counnew_0/a_n772_18858# newdene_0/counnew_0/a_n1092_18858# newdene_0/counnew_0/gnd newdene_0/counnew_0/gnd sky130_fd_pr__nfet_01v8 ad=0.42 pd=2.6 as=0.42 ps=2.6 w=0.7 l=0.2
X362 newdene_0/counnew_0/a_828_14878# newdene_0/counnew_0/a_n92_13478# newdene_0/counnew_0/a_648_14878# newdene_0/counnew_0/gnd sky130_fd_pr__nfet_01v8 ad=0.3 pd=1.6 as=0.3 ps=1.6 w=1 l=0.3
X363 VDPWR newdene_0/counnew_0/a_n4372_13478# newdene_0/counnew_0/a_n3632_14218# VDPWR sky130_fd_pr__pfet_01v8 ad=0.45 pd=2.1 as=0.45 ps=2.1 w=1.5 l=0.3
X364 newdene_0/counnew_0/a_2788_14218# rst_n newdene_0/counnew_0/a_2968_14878# newdene_0/counnew_0/gnd sky130_fd_pr__nfet_01v8 ad=0.6 pd=3.2 as=0.3 ps=1.6 w=1 l=0.3
X365 newdene_0/counnew_0/a_n3452_15558# newdene_0/counnew_0/a_n4472_13338# newdene_0/counnew_0/a_n3632_15558# newdene_0/counnew_0/gnd sky130_fd_pr__nfet_01v8 ad=0.3 pd=1.6 as=0.3 ps=1.6 w=1 l=0.3
X366 VDPWR newdene_0/counnew_0/a_4568_16918# newdene_0/counnew_0/a_4268_15878# VDPWR sky130_fd_pr__pfet_01v8 ad=0.45 pd=2.1 as=0.45 ps=2.1 w=1.5 l=0.3
X367 VDPWR newdene_0/counnew_0/a_n2332_13338# uo_out[5] VDPWR sky130_fd_pr__pfet_01v8 ad=0.45 pd=2.1 as=0.45 ps=2.1 w=1.5 l=0.3
X368 newdene_0/counnew_0/a_4908_16918# newdene_0/counnew_0/a_3508_18858# newdene_0/counnew_0/a_4568_16918# VDPWR sky130_fd_pr__pfet_01v8 ad=0.75 pd=3.1 as=1.5 ps=6.2 w=2.5 l=0.2
X369 newdene_0/counnew_0/gnd uo_out[3] newdene_0/counnew_0/a_2888_16878# newdene_0/counnew_0/gnd sky130_fd_pr__nfet_01v8 ad=0.6 pd=3.2 as=0.6 ps=3.2 w=1 l=0.2
X370 newdene_0/counnew_0/a_n6012_15878# rst_n VDPWR VDPWR sky130_fd_pr__pfet_01v8 ad=0.9 pd=4.2 as=0.45 ps=2.1 w=1.5 l=0.3
X371 newdene_0/counnew_0/a_9188_16918# newdene_0/counnew_0/a_7788_18858# newdene_0/counnew_0/a_8848_16918# VDPWR sky130_fd_pr__pfet_01v8 ad=0.75 pd=3.1 as=1.5 ps=6.2 w=2.5 l=0.2
X372 newdene_0/counnew_0/a_2428_16918# uo_out[3] newdene_0/counnew_0/a_2268_16918# VDPWR sky130_fd_pr__pfet_01v8 ad=1.5 pd=6.2 as=0.75 ps=3.1 w=2.5 l=0.2
X373 newdene_0/counnew_0/a_2228_12918# newdene_0/AND_0/out newdene_0/counnew_0/a_2048_12918# newdene_0/counnew_0/gnd sky130_fd_pr__nfet_01v8 ad=0.3 pd=1.6 as=0.3 ps=1.6 w=1 l=0.3
X374 VDPWR newdene_0/counnew_0/a_n5252_16878# newdene_0/counnew_0/a_n5372_16918# VDPWR sky130_fd_pr__pfet_01v8 ad=1.5 pd=6.2 as=0.75 ps=3.1 w=2.5 l=0.2
X375 newdene_0/counnew_0/a_1888_16918# newdene_0/counnew_0/a_1368_18858# newdene_0/counnew_0/gnd newdene_0/counnew_0/gnd sky130_fd_pr__nfet_01v8 ad=0.6 pd=3.2 as=0.6 ps=3.2 w=1 l=0.2
X376 newdene_0/counnew_0/gnd uo_out[0] newdene_0/counnew_0/a_9308_16878# newdene_0/counnew_0/gnd sky130_fd_pr__nfet_01v8 ad=0.6 pd=3.2 as=0.6 ps=3.2 w=1 l=0.2
X377 newdene_0/counnew_0/a_n6252_16918# VDPWR VDPWR VDPWR sky130_fd_pr__pfet_01v8 ad=1.5 pd=6.2 as=1.5 ps=6.2 w=2.5 l=0.2
X378 newdene_0/counnew_0/gnd newdene_0/counnew_0/a_2888_16878# newdene_0/counnew_0/a_2768_17818# newdene_0/counnew_0/gnd sky130_fd_pr__nfet_01v8 ad=0.6 pd=3.2 as=0.3 ps=1.6 w=1 l=0.2
X379 uo_out[4] newdene_0/counnew_0/a_648_14218# VDPWR VDPWR sky130_fd_pr__pfet_01v8 ad=0.9 pd=4.2 as=0.45 ps=2.1 w=1.5 l=0.3
X380 newdene_0/counnew_0/a_2268_17818# uo_out[3] newdene_0/counnew_0/gnd newdene_0/counnew_0/gnd sky130_fd_pr__nfet_01v8 ad=0.3 pd=1.6 as=0.6 ps=3.2 w=1 l=0.2
X381 newdene_0/counnew_0/a_n5712_16918# VDPWR newdene_0/counnew_0/a_n5872_17818# newdene_0/counnew_0/gnd sky130_fd_pr__nfet_01v8 ad=0.6 pd=3.2 as=0.3 ps=1.6 w=1 l=0.2
X382 newdene_0/counnew_0/a_6168_16918# newdene_0/counnew_0/a_5648_18858# newdene_0/counnew_0/gnd newdene_0/counnew_0/gnd sky130_fd_pr__nfet_01v8 ad=0.6 pd=3.2 as=0.6 ps=3.2 w=1 l=0.2
X383 newdene_0/counnew_0/a_8648_12918# newdene_0/AND_0/out newdene_0/counnew_0/a_8468_12918# newdene_0/counnew_0/gnd sky130_fd_pr__nfet_01v8 ad=0.3 pd=1.6 as=0.3 ps=1.6 w=1 l=0.3
X384 newdene_0/counnew_0/a_n2152_15878# rst_n VDPWR VDPWR sky130_fd_pr__pfet_01v8 ad=0.9 pd=4.2 as=0.45 ps=2.1 w=1.5 l=0.3
X385 VDPWR newdene_0/AND_0/out newdene_0/counnew_0/a_6228_13338# VDPWR sky130_fd_pr__pfet_01v8 ad=0.45 pd=2.1 as=0.45 ps=2.1 w=1.5 l=0.3
X386 newdene_0/counnew_0/gnd newdene_0/counnew_0/a_7168_16878# newdene_0/counnew_0/a_7048_17818# newdene_0/counnew_0/gnd sky130_fd_pr__nfet_01v8 ad=0.6 pd=3.2 as=0.3 ps=1.6 w=1 l=0.2
X387 VDPWR newdene_0/AND_0/out newdene_0/counnew_0/a_n92_13478# VDPWR sky130_fd_pr__pfet_01v8 ad=0.45 pd=2.1 as=0.45 ps=2.1 w=1.5 l=0.3
X388 newdene_0/counnew_0/a_n5352_14218# uo_out[7] VDPWR VDPWR sky130_fd_pr__pfet_01v8 ad=0.45 pd=2.1 as=0.9 ps=4.2 w=1.5 l=0.3
X389 newdene_0/counnew_0/a_6508_15558# newdene_0/counnew_0/a_6408_15878# newdene_0/counnew_0/a_6328_15558# newdene_0/counnew_0/gnd sky130_fd_pr__nfet_01v8 ad=0.3 pd=1.6 as=0.3 ps=1.6 w=1 l=0.3
X390 newdene_0/counnew_0/a_n5352_15558# VDPWR newdene_0/counnew_0/gnd newdene_0/counnew_0/gnd sky130_fd_pr__nfet_01v8 ad=0.3 pd=1.6 as=0.6 ps=3.2 w=1 l=0.3
X391 VDPWR newdene_0/counnew_0/a_n1392_16878# newdene_0/counnew_0/a_n1512_16918# VDPWR sky130_fd_pr__pfet_01v8 ad=1.5 pd=6.2 as=0.75 ps=3.1 w=2.5 l=0.2
X392 newdene_0/counnew_0/a_8688_17818# uo_out[0] newdene_0/counnew_0/gnd newdene_0/counnew_0/gnd sky130_fd_pr__nfet_01v8 ad=0.3 pd=1.6 as=0.6 ps=3.2 w=1 l=0.2
X393 newdene_0/counnew_0/a_5328_18858# newdene_0/counnew_0/a_3508_18858# VDPWR VDPWR sky130_fd_pr__pfet_01v8 ad=0.36 pd=1.8 as=0.72 ps=3.6 w=1.2 l=0.2
X394 newdene_0/counnew_0/a_9388_14878# newdene_0/counnew_0/a_8468_13478# newdene_0/counnew_0/a_9208_14878# newdene_0/counnew_0/gnd sky130_fd_pr__nfet_01v8 ad=0.3 pd=1.6 as=0.3 ps=1.6 w=1 l=0.3
X395 newdene_0/counnew_0/a_n1852_16918# newdene_0/counnew_0/a_n2912_18858# newdene_0/counnew_0/a_n2012_17818# newdene_0/counnew_0/gnd sky130_fd_pr__nfet_01v8 ad=0.6 pd=3.2 as=0.3 ps=1.6 w=1 l=0.2
X396 newdene_0/counnew_0/a_n6192_14578# newdene_0/counnew_0/a_n6192_13338# VDPWR VDPWR sky130_fd_pr__pfet_01v8 ad=0.9 pd=4.2 as=0.45 ps=2.1 w=1.5 l=0.3
X397 newdene_0/counnew_0/a_n3632_12918# newdene_0/counnew_0/a_n4372_13478# newdene_0/counnew_0/gnd newdene_0/counnew_0/gnd sky130_fd_pr__nfet_01v8 ad=0.3 pd=1.6 as=0.6 ps=3.2 w=1 l=0.3
X398 VDPWR newdene_0/counnew_0/a_288_16918# newdene_0/counnew_0/a_n12_15878# VDPWR sky130_fd_pr__pfet_01v8 ad=0.45 pd=2.1 as=0.45 ps=2.1 w=1.5 l=0.3
X399 newdene_0/counnew_0/a_n1492_14218# uo_out[5] VDPWR VDPWR sky130_fd_pr__pfet_01v8 ad=0.45 pd=2.1 as=0.9 ps=4.2 w=1.5 l=0.3
X400 newdene_0/counnew_0/a_8468_12918# newdene_0/counnew_0/a_8368_13338# newdene_0/counnew_0/gnd newdene_0/counnew_0/gnd sky130_fd_pr__nfet_01v8 ad=0.3 pd=1.6 as=0.6 ps=3.2 w=1 l=0.3
X401 newdene_0/counnew_0/a_n252_16918# newdene_0/counnew_0/a_n772_18858# VDPWR VDPWR sky130_fd_pr__pfet_01v8 ad=1.5 pd=6.2 as=1.5 ps=6.2 w=2.5 l=0.2
X402 newdene_0/counnew_0/a_n1492_15558# VDPWR newdene_0/counnew_0/gnd newdene_0/counnew_0/gnd sky130_fd_pr__nfet_01v8 ad=0.3 pd=1.6 as=0.6 ps=3.2 w=1 l=0.3
X403 newdene_0/counnew_0/a_2128_15878# rst_n VDPWR VDPWR sky130_fd_pr__pfet_01v8 ad=0.9 pd=4.2 as=0.45 ps=2.1 w=1.5 l=0.3
X404 newdene_0/counnew_0/a_n4372_13478# newdene_0/counnew_0/a_n4292_15878# newdene_0/counnew_0/a_n4192_12918# newdene_0/counnew_0/gnd sky130_fd_pr__nfet_01v8 ad=0.6 pd=3.2 as=0.3 ps=1.6 w=1 l=0.3
X405 newdene_0/counnew_0/a_1048_18478# newdene_0/counnew_0/a_n772_18858# newdene_0/counnew_0/gnd newdene_0/counnew_0/gnd sky130_fd_pr__nfet_01v8 ad=0.21 pd=1.3 as=0.42 ps=2.6 w=0.7 l=0.2
X406 newdene_0/counnew_0/a_n4372_14878# newdene_0/counnew_0/a_n4472_14578# newdene_0/counnew_0/gnd newdene_0/counnew_0/gnd sky130_fd_pr__nfet_01v8 ad=0.3 pd=1.6 as=0.6 ps=3.2 w=1 l=0.3
X407 newdene_0/counnew_0/a_4088_14578# VDPWR VDPWR VDPWR sky130_fd_pr__pfet_01v8 ad=0.45 pd=2.1 as=0.9 ps=4.2 w=1.5 l=0.3
X408 uo_out[0] newdene_0/counnew_0/a_9208_14218# VDPWR VDPWR sky130_fd_pr__pfet_01v8 ad=0.9 pd=4.2 as=0.45 ps=2.1 w=1.5 l=0.3
X409 newdene_0/counnew_0/a_7468_18478# newdene_0/counnew_0/a_5648_18858# newdene_0/counnew_0/gnd newdene_0/counnew_0/gnd sky130_fd_pr__nfet_01v8 ad=0.21 pd=1.3 as=0.42 ps=2.6 w=0.7 l=0.2
X410 newdene_0/counnew_0/a_n3452_12918# newdene_0/counnew_0/a_n3992_16918# newdene_0/counnew_0/a_n3632_12918# newdene_0/counnew_0/gnd sky130_fd_pr__nfet_01v8 ad=0.3 pd=1.6 as=0.3 ps=1.6 w=1 l=0.3
X411 newdene_0/counnew_0/a_4088_13338# rst_n VDPWR VDPWR sky130_fd_pr__pfet_01v8 ad=0.9 pd=4.2 as=0.45 ps=2.1 w=1.5 l=0.3
X412 newdene_0/counnew_0/a_2768_16918# newdene_0/counnew_0/a_1368_18858# newdene_0/counnew_0/a_2428_16918# VDPWR sky130_fd_pr__pfet_01v8 ad=0.75 pd=3.1 as=1.5 ps=6.2 w=2.5 l=0.2
X413 newdene_0/counnew_0/a_4088_14578# newdene_0/counnew_0/a_4088_13338# newdene_0/counnew_0/a_4368_15558# newdene_0/counnew_0/gnd sky130_fd_pr__nfet_01v8 ad=0.6 pd=3.2 as=0.3 ps=1.6 w=1 l=0.3
X414 newdene_0/counnew_0/a_7048_16918# newdene_0/counnew_0/a_5648_18858# newdene_0/counnew_0/a_6708_16918# VDPWR sky130_fd_pr__pfet_01v8 ad=0.75 pd=3.1 as=1.5 ps=6.2 w=2.5 l=0.2
X415 newdene_0/counnew_0/a_7068_14218# rst_n newdene_0/counnew_0/a_7248_14878# newdene_0/counnew_0/gnd sky130_fd_pr__nfet_01v8 ad=0.6 pd=3.2 as=0.3 ps=1.6 w=1 l=0.3
X416 VDPWR newdene_0/counnew_0/a_8848_16918# newdene_0/counnew_0/a_8548_15878# VDPWR sky130_fd_pr__pfet_01v8 ad=0.45 pd=2.1 as=0.45 ps=2.1 w=1.5 l=0.3
X417 VDPWR newdene_0/AND_0/out newdene_0/counnew_0/a_n6192_13338# VDPWR sky130_fd_pr__pfet_01v8 ad=0.45 pd=2.1 as=0.45 ps=2.1 w=1.5 l=0.3
X418 newdene_0/counnew_0/a_n5912_15558# newdene_0/counnew_0/a_n6012_15878# newdene_0/counnew_0/a_n6092_15558# newdene_0/counnew_0/gnd sky130_fd_pr__nfet_01v8 ad=0.3 pd=1.6 as=0.3 ps=1.6 w=1 l=0.3
X419 newdene_0/counnew_0/gnd uo_out[1] newdene_0/counnew_0/a_7168_16878# newdene_0/counnew_0/gnd sky130_fd_pr__nfet_01v8 ad=0.6 pd=3.2 as=0.6 ps=3.2 w=1 l=0.2
X420 VDPWR uo_out[6] newdene_0/counnew_0/a_n3232_18858# VDPWR sky130_fd_pr__pfet_01v8 ad=0.36 pd=1.8 as=0.36 ps=1.8 w=1.2 l=0.2
X421 newdene_0/counnew_0/a_6708_16918# uo_out[1] newdene_0/counnew_0/a_6548_16918# VDPWR sky130_fd_pr__pfet_01v8 ad=1.5 pd=6.2 as=0.75 ps=3.1 w=2.5 l=0.2
X422 newdene_0/counnew_0/a_6508_12918# newdene_0/AND_0/out newdene_0/counnew_0/a_6328_12918# newdene_0/counnew_0/gnd sky130_fd_pr__nfet_01v8 ad=0.3 pd=1.6 as=0.3 ps=1.6 w=1 l=0.3
X423 VDPWR newdene_0/AND_0/out newdene_0/counnew_0/a_4088_13338# VDPWR sky130_fd_pr__pfet_01v8 ad=0.45 pd=2.1 as=0.45 ps=2.1 w=1.5 l=0.3
X424 newdene_0/counnew_0/a_n5352_12918# newdene_0/counnew_0/a_n6092_13478# newdene_0/counnew_0/gnd newdene_0/counnew_0/gnd sky130_fd_pr__nfet_01v8 ad=0.3 pd=1.6 as=0.6 ps=3.2 w=1 l=0.3
X425 newdene_0/counnew_0/a_2968_14878# newdene_0/counnew_0/a_2048_13478# newdene_0/counnew_0/a_2788_14878# newdene_0/counnew_0/gnd sky130_fd_pr__nfet_01v8 ad=0.3 pd=1.6 as=0.3 ps=1.6 w=1 l=0.3
X426 newdene_0/counnew_0/gnd newdene_0/counnew_0/a_5028_16878# newdene_0/counnew_0/a_4908_17818# newdene_0/counnew_0/gnd sky130_fd_pr__nfet_01v8 ad=0.6 pd=3.2 as=0.3 ps=1.6 w=1 l=0.2
X427 newdene_0/counnew_0/a_4368_15558# newdene_0/counnew_0/a_4268_15878# newdene_0/counnew_0/a_4188_15558# newdene_0/counnew_0/gnd sky130_fd_pr__nfet_01v8 ad=0.3 pd=1.6 as=0.3 ps=1.6 w=1 l=0.3
X428 VDPWR newdene_0/counnew_0/a_2128_15878# newdene_0/counnew_0/a_1948_14578# VDPWR sky130_fd_pr__pfet_01v8 ad=0.45 pd=2.1 as=0.45 ps=2.1 w=1.5 l=0.3
X429 newdene_0/counnew_0/a_n4372_13478# newdene_0/counnew_0/a_n4472_13338# VDPWR VDPWR sky130_fd_pr__pfet_01v8 ad=0.45 pd=2.1 as=0.9 ps=4.2 w=1.5 l=0.3
X430 newdene_0/counnew_0/a_6548_17818# uo_out[1] newdene_0/counnew_0/gnd newdene_0/counnew_0/gnd sky130_fd_pr__nfet_01v8 ad=0.3 pd=1.6 as=0.6 ps=3.2 w=1 l=0.2
X431 newdene_0/counnew_0/a_3188_18858# newdene_0/counnew_0/a_1368_18858# VDPWR VDPWR sky130_fd_pr__pfet_01v8 ad=0.36 pd=1.8 as=0.72 ps=3.6 w=1.2 l=0.2
X432 newdene_0/counnew_0/a_n4152_16918# newdene_0/counnew_0/a_n4532_16918# VDPWR VDPWR sky130_fd_pr__pfet_01v8 ad=0.75 pd=3.1 as=1.5 ps=6.2 w=2.5 l=0.2
X433 VDPWR newdene_0/counnew_0/a_8548_15878# newdene_0/counnew_0/a_8368_14578# VDPWR sky130_fd_pr__pfet_01v8 ad=0.45 pd=2.1 as=0.45 ps=2.1 w=1.5 l=0.3
X434 newdene_0/counnew_0/a_n1492_12918# newdene_0/counnew_0/a_n2232_13478# newdene_0/counnew_0/gnd newdene_0/counnew_0/gnd sky130_fd_pr__nfet_01v8 ad=0.3 pd=1.6 as=0.6 ps=3.2 w=1 l=0.3
X435 newdene_0/counnew_0/a_n3992_16918# uo_out[7] newdene_0/counnew_0/a_n4152_17818# newdene_0/counnew_0/gnd sky130_fd_pr__nfet_01v8 ad=0.6 pd=3.2 as=0.3 ps=1.6 w=1 l=0.2
X436 VDPWR uo_out[6] newdene_0/counnew_0/a_n3532_16878# VDPWR sky130_fd_pr__pfet_01v8 ad=1.5 pd=6.2 as=1.5 ps=6.2 w=2.5 l=0.2
X437 newdene_0/counnew_0/a_648_14218# uo_out[4] VDPWR VDPWR sky130_fd_pr__pfet_01v8 ad=0.45 pd=2.1 as=0.9 ps=4.2 w=1.5 l=0.3
X438 newdene_0/counnew_0/a_n2332_13338# rst_n VDPWR VDPWR sky130_fd_pr__pfet_01v8 ad=0.9 pd=4.2 as=0.45 ps=2.1 w=1.5 l=0.3
X439 newdene_0/counnew_0/a_648_15558# VDPWR newdene_0/counnew_0/gnd newdene_0/counnew_0/gnd sky130_fd_pr__nfet_01v8 ad=0.3 pd=1.6 as=0.6 ps=3.2 w=1 l=0.3
X440 newdene_0/counnew_0/a_n3632_14218# rst_n newdene_0/counnew_0/a_n3452_14878# newdene_0/counnew_0/gnd sky130_fd_pr__nfet_01v8 ad=0.6 pd=3.2 as=0.3 ps=1.6 w=1 l=0.3
X441 newdene_0/counnew_0/a_n2332_14578# newdene_0/counnew_0/a_n2332_13338# newdene_0/counnew_0/a_n2052_15558# newdene_0/counnew_0/gnd sky130_fd_pr__nfet_01v8 ad=0.6 pd=3.2 as=0.3 ps=1.6 w=1 l=0.3
X442 newdene_0/counnew_0/a_n3652_17818# newdene_0/counnew_0/a_n4532_16918# newdene_0/counnew_0/a_n3992_16918# newdene_0/counnew_0/gnd sky130_fd_pr__nfet_01v8 ad=0.3 pd=1.6 as=0.6 ps=3.2 w=1 l=0.2
X443 newdene_0/counnew_0/a_6408_15878# rst_n VDPWR VDPWR sky130_fd_pr__pfet_01v8 ad=0.9 pd=4.2 as=0.45 ps=2.1 w=1.5 l=0.3
X444 uo_out[6] VDPWR VDPWR VDPWR sky130_fd_pr__pfet_01v8 ad=0.45 pd=2.1 as=0.9 ps=4.2 w=1.5 l=0.3
X445 newdene_0/counnew_0/a_288_16918# uo_out[4] newdene_0/counnew_0/a_128_16918# VDPWR sky130_fd_pr__pfet_01v8 ad=1.5 pd=6.2 as=0.75 ps=3.1 w=2.5 l=0.2
X446 newdene_0/counnew_0/a_8368_14578# VDPWR VDPWR VDPWR sky130_fd_pr__pfet_01v8 ad=0.45 pd=2.1 as=0.9 ps=4.2 w=1.5 l=0.3
X447 newdene_0/counnew_0/a_n4472_14578# newdene_0/counnew_0/a_n4472_13338# VDPWR VDPWR sky130_fd_pr__pfet_01v8 ad=0.9 pd=4.2 as=0.45 ps=2.1 w=1.5 l=0.3
X448 newdene_0/counnew_0/gnd newdene_0/counnew_0/a_748_16878# newdene_0/counnew_0/a_628_17818# newdene_0/counnew_0/gnd sky130_fd_pr__nfet_01v8 ad=0.6 pd=3.2 as=0.3 ps=1.6 w=1 l=0.2
X449 newdene_0/counnew_0/a_4188_13478# newdene_0/counnew_0/a_4268_15878# newdene_0/counnew_0/a_4368_12918# newdene_0/counnew_0/gnd sky130_fd_pr__nfet_01v8 ad=0.6 pd=3.2 as=0.3 ps=1.6 w=1 l=0.3
X450 newdene_0/counnew_0/a_1948_13338# rst_n VDPWR VDPWR sky130_fd_pr__pfet_01v8 ad=0.9 pd=4.2 as=0.45 ps=2.1 w=1.5 l=0.3
X451 VDPWR newdene_0/counnew_0/a_2428_16918# newdene_0/counnew_0/a_2128_15878# VDPWR sky130_fd_pr__pfet_01v8 ad=0.45 pd=2.1 as=0.45 ps=2.1 w=1.5 l=0.3
X452 newdene_0/counnew_0/a_1948_14578# newdene_0/counnew_0/a_1948_13338# newdene_0/counnew_0/a_2228_15558# newdene_0/counnew_0/gnd sky130_fd_pr__nfet_01v8 ad=0.6 pd=3.2 as=0.3 ps=1.6 w=1 l=0.3
X453 newdene_0/counnew_0/a_2048_14878# newdene_0/counnew_0/a_1948_14578# newdene_0/counnew_0/gnd newdene_0/counnew_0/gnd sky130_fd_pr__nfet_01v8 ad=0.3 pd=1.6 as=0.6 ps=3.2 w=1 l=0.3
X454 newdene_0/counnew_0/a_4928_14218# rst_n newdene_0/counnew_0/a_5108_14878# newdene_0/counnew_0/gnd sky130_fd_pr__nfet_01v8 ad=0.6 pd=3.2 as=0.3 ps=1.6 w=1 l=0.3
X455 newdene_0/counnew_0/a_4928_14218# uo_out[2] VDPWR VDPWR sky130_fd_pr__pfet_01v8 ad=0.45 pd=2.1 as=0.9 ps=4.2 w=1.5 l=0.3
X456 VDPWR newdene_0/counnew_0/a_n4472_13338# uo_out[6] VDPWR sky130_fd_pr__pfet_01v8 ad=0.45 pd=2.1 as=0.45 ps=2.1 w=1.5 l=0.3
X457 newdene_0/counnew_0/a_n5912_12918# newdene_0/AND_0/out newdene_0/counnew_0/a_n6092_12918# newdene_0/counnew_0/gnd sky130_fd_pr__nfet_01v8 ad=0.3 pd=1.6 as=0.3 ps=1.6 w=1 l=0.3
X458 newdene_0/counnew_0/a_8368_13338# rst_n VDPWR VDPWR sky130_fd_pr__pfet_01v8 ad=0.9 pd=4.2 as=0.45 ps=2.1 w=1.5 l=0.3
X459 newdene_0/counnew_0/a_6328_14878# newdene_0/counnew_0/a_6228_14578# newdene_0/counnew_0/gnd newdene_0/counnew_0/gnd sky130_fd_pr__nfet_01v8 ad=0.3 pd=1.6 as=0.6 ps=3.2 w=1 l=0.3
X460 newdene_0/counnew_0/a_n5172_14878# newdene_0/counnew_0/a_n6092_13478# newdene_0/counnew_0/a_n5352_14878# newdene_0/counnew_0/gnd sky130_fd_pr__nfet_01v8 ad=0.3 pd=1.6 as=0.3 ps=1.6 w=1 l=0.3
X461 newdene_0/counnew_0/a_8368_14578# newdene_0/counnew_0/a_8368_13338# newdene_0/counnew_0/a_8648_15558# newdene_0/counnew_0/gnd sky130_fd_pr__nfet_01v8 ad=0.6 pd=3.2 as=0.3 ps=1.6 w=1 l=0.3
X462 newdene_0/counnew_0/a_4928_15558# VDPWR newdene_0/counnew_0/gnd newdene_0/counnew_0/gnd sky130_fd_pr__nfet_01v8 ad=0.3 pd=1.6 as=0.6 ps=3.2 w=1 l=0.3
X463 newdene_0/counnew_0/a_9208_14218# uo_out[0] VDPWR VDPWR sky130_fd_pr__pfet_01v8 ad=0.45 pd=2.1 as=0.9 ps=4.2 w=1.5 l=0.3
X464 newdene_0/counnew_0/a_128_17818# uo_out[4] newdene_0/counnew_0/gnd newdene_0/counnew_0/gnd sky130_fd_pr__nfet_01v8 ad=0.3 pd=1.6 as=0.6 ps=3.2 w=1 l=0.2
X465 newdene_0/counnew_0/a_4568_16918# uo_out[2] newdene_0/counnew_0/a_4408_16918# VDPWR sky130_fd_pr__pfet_01v8 ad=1.5 pd=6.2 as=0.75 ps=3.1 w=2.5 l=0.2
X466 newdene_0/counnew_0/a_9208_15558# VDPWR newdene_0/counnew_0/gnd newdene_0/counnew_0/gnd sky130_fd_pr__nfet_01v8 ad=0.3 pd=1.6 as=0.6 ps=3.2 w=1 l=0.3
X467 newdene_0/counnew_0/a_4368_12918# newdene_0/AND_0/out newdene_0/counnew_0/a_4188_12918# newdene_0/counnew_0/gnd sky130_fd_pr__nfet_01v8 ad=0.3 pd=1.6 as=0.3 ps=1.6 w=1 l=0.3
X468 newdene_0/counnew_0/a_1048_18858# newdene_0/counnew_0/a_n772_18858# VDPWR VDPWR sky130_fd_pr__pfet_01v8 ad=0.36 pd=1.8 as=0.72 ps=3.6 w=1.2 l=0.2
X469 newdene_0/counnew_0/a_n1312_14878# newdene_0/counnew_0/a_n2232_13478# newdene_0/counnew_0/a_n1492_14878# newdene_0/counnew_0/gnd sky130_fd_pr__nfet_01v8 ad=0.3 pd=1.6 as=0.3 ps=1.6 w=1 l=0.3
X470 newdene_0/counnew_0/a_n4292_15878# rst_n VDPWR VDPWR sky130_fd_pr__pfet_01v8 ad=0.9 pd=4.2 as=0.45 ps=2.1 w=1.5 l=0.3
X471 newdene_0/counnew_0/a_n2012_16918# newdene_0/counnew_0/a_n2392_16918# VDPWR VDPWR sky130_fd_pr__pfet_01v8 ad=0.75 pd=3.1 as=1.5 ps=6.2 w=2.5 l=0.2
X472 newdene_0/counnew_0/gnd newdene_0/counnew_0/a_9308_16878# newdene_0/counnew_0/a_9188_17818# newdene_0/counnew_0/gnd sky130_fd_pr__nfet_01v8 ad=0.6 pd=3.2 as=0.3 ps=1.6 w=1 l=0.2
X473 VDPWR newdene_0/AND_0/out newdene_0/counnew_0/a_n4472_13338# VDPWR sky130_fd_pr__pfet_01v8 ad=0.45 pd=2.1 as=0.45 ps=2.1 w=1.5 l=0.3
X474 VDPWR newdene_0/counnew_0/a_6408_15878# newdene_0/counnew_0/a_6228_14578# VDPWR sky130_fd_pr__pfet_01v8 ad=0.45 pd=2.1 as=0.45 ps=2.1 w=1.5 l=0.3
X475 uo_out[7] VDPWR VDPWR VDPWR sky130_fd_pr__pfet_01v8 ad=0.45 pd=2.1 as=0.9 ps=4.2 w=1.5 l=0.3
X476 VDPWR newdene_0/counnew_0/a_n3532_16878# newdene_0/counnew_0/a_n3652_16918# VDPWR sky130_fd_pr__pfet_01v8 ad=1.5 pd=6.2 as=0.75 ps=3.1 w=2.5 l=0.2
X477 newdene_0/counnew_0/a_n5372_17818# newdene_0/counnew_0/a_n6252_16918# newdene_0/counnew_0/a_n5712_16918# newdene_0/counnew_0/gnd sky130_fd_pr__nfet_01v8 ad=0.3 pd=1.6 as=0.6 ps=3.2 w=1 l=0.2
X478 newdene_0/counnew_0/a_7468_18858# newdene_0/counnew_0/a_5648_18858# VDPWR VDPWR sky130_fd_pr__pfet_01v8 ad=0.36 pd=1.8 as=0.72 ps=3.6 w=1.2 l=0.2
X479 newdene_0/counnew_0/a_n4192_15558# newdene_0/counnew_0/a_n4292_15878# newdene_0/counnew_0/a_n4372_15558# newdene_0/counnew_0/gnd sky130_fd_pr__nfet_01v8 ad=0.3 pd=1.6 as=0.3 ps=1.6 w=1 l=0.3
X480 newdene_0/counnew_0/a_n4532_16918# uo_out[7] VDPWR VDPWR sky130_fd_pr__pfet_01v8 ad=1.5 pd=6.2 as=1.5 ps=6.2 w=2.5 l=0.2
X481 newdene_0/counnew_0/a_648_12918# newdene_0/counnew_0/a_n92_13478# newdene_0/counnew_0/gnd newdene_0/counnew_0/gnd sky130_fd_pr__nfet_01v8 ad=0.3 pd=1.6 as=0.6 ps=3.2 w=1 l=0.3
X482 VDPWR uo_out[5] newdene_0/counnew_0/a_n1392_16878# VDPWR sky130_fd_pr__pfet_01v8 ad=1.5 pd=6.2 as=1.5 ps=6.2 w=2.5 l=0.2
X483 newdene_0/counnew_0/a_n2232_13478# newdene_0/counnew_0/a_n2152_15878# newdene_0/counnew_0/a_n2052_12918# newdene_0/counnew_0/gnd sky130_fd_pr__nfet_01v8 ad=0.6 pd=3.2 as=0.3 ps=1.6 w=1 l=0.3
X484 newdene_0/counnew_0/a_648_14218# rst_n newdene_0/counnew_0/a_828_14878# newdene_0/counnew_0/gnd sky130_fd_pr__nfet_01v8 ad=0.6 pd=3.2 as=0.3 ps=1.6 w=1 l=0.3
X485 newdene_0/counnew_0/a_2048_13478# newdene_0/counnew_0/a_1948_13338# VDPWR VDPWR sky130_fd_pr__pfet_01v8 ad=0.45 pd=2.1 as=0.9 ps=4.2 w=1.5 l=0.3
X486 newdene_0/counnew_0/a_n1512_17818# newdene_0/counnew_0/a_n2392_16918# newdene_0/counnew_0/a_n1852_16918# newdene_0/counnew_0/gnd sky130_fd_pr__nfet_01v8 ad=0.3 pd=1.6 as=0.6 ps=3.2 w=1 l=0.2
X487 newdene_0/counnew_0/a_4268_15878# rst_n VDPWR VDPWR sky130_fd_pr__pfet_01v8 ad=0.9 pd=4.2 as=0.45 ps=2.1 w=1.5 l=0.3
X488 uo_out[5] VDPWR VDPWR VDPWR sky130_fd_pr__pfet_01v8 ad=0.45 pd=2.1 as=0.9 ps=4.2 w=1.5 l=0.3
X489 newdene_0/counnew_0/a_6328_13478# newdene_0/counnew_0/a_6228_13338# VDPWR VDPWR sky130_fd_pr__pfet_01v8 ad=0.45 pd=2.1 as=0.9 ps=4.2 w=1.5 l=0.3
X490 VDPWR uo_out[4] newdene_0/counnew_0/a_748_16878# VDPWR sky130_fd_pr__pfet_01v8 ad=1.5 pd=6.2 as=1.5 ps=6.2 w=2.5 l=0.2
X491 VDPWR newdene_0/counnew_0/a_n5712_16918# newdene_0/counnew_0/a_n6012_15878# VDPWR sky130_fd_pr__pfet_01v8 ad=0.45 pd=2.1 as=0.45 ps=2.1 w=1.5 l=0.3
X492 VDPWR newdene_0/counnew_0/a_6328_13478# newdene_0/counnew_0/a_7068_14218# VDPWR sky130_fd_pr__pfet_01v8 ad=0.45 pd=2.1 as=0.45 ps=2.1 w=1.5 l=0.3
X493 newdene_0/counnew_0/a_n6192_13338# newdene_0/counnew_0/a_n6192_14578# VDPWR VDPWR sky130_fd_pr__pfet_01v8 ad=0.45 pd=2.1 as=0.9 ps=4.2 w=1.5 l=0.3
X494 newdene_0/counnew_0/a_7248_15558# newdene_0/counnew_0/a_6228_13338# newdene_0/counnew_0/a_7068_15558# newdene_0/counnew_0/gnd sky130_fd_pr__nfet_01v8 ad=0.3 pd=1.6 as=0.3 ps=1.6 w=1 l=0.3
X495 newdene_0/counnew_0/a_2048_13478# newdene_0/counnew_0/a_2128_15878# newdene_0/counnew_0/a_2228_12918# newdene_0/counnew_0/gnd sky130_fd_pr__nfet_01v8 ad=0.6 pd=3.2 as=0.3 ps=1.6 w=1 l=0.3
X496 newdene_0/counnew_0/a_n6092_15558# VDPWR newdene_0/counnew_0/gnd newdene_0/counnew_0/gnd sky130_fd_pr__nfet_01v8 ad=0.3 pd=1.6 as=0.6 ps=3.2 w=1 l=0.3
X497 VDPWR newdene_0/sw1cs_0/a_n660_5160# newdene_0/sw1cs_0/a_n780_5200# VDPWR sky130_fd_pr__pfet_01v8 ad=0.6 pd=3.2 as=0.6 ps=3.2 w=1 l=1
X498 ua[0] newdene_0/li_7710_n8950# newdene_0/sw1cs_0/a_n780_5200# VDPWR sky130_fd_pr__pfet_01v8 ad=0.3 pd=2.2 as=0.3 ps=2.2 w=0.5 l=0.2
X499 newdene_0/m2_4740_n7410# ui_in[2] newdene_0/sw1cs_0/a_n660_5160# VGND sky130_fd_pr__nfet_01v8 ad=2.4 pd=9.2 as=2.4 ps=9.2 w=4 l=0.2
X500 VDPWR ui_in[2] newdene_0/sw1cs_0/a_n660_5160# VDPWR sky130_fd_pr__pfet_01v8 ad=1.2 pd=5.2 as=1.2 ps=5.2 w=2 l=0.2
X501 VDPWR ui_in[2] newdene_0/li_7710_n8950# VDPWR sky130_fd_pr__pfet_01v8 ad=3 pd=11.2 as=1.5 ps=5.6 w=5 l=0.2
X502 VDPWR ui_in[0] newdene_0/li_7680_n13980# VDPWR sky130_fd_pr__pfet_01v8 ad=3 pd=11.2 as=1.5 ps=5.6 w=5 l=0.2
X503 newdene_0/li_7690_n11680# newdene_0/sw_0/a_n540_n2470# VDPWR VDPWR sky130_fd_pr__pfet_01v8 ad=1.5 pd=5.6 as=3 ps=11.2 w=5 l=0.2
X504 newdene_0/sw_0/a_n540_120# newdene_0/li_5730_n12230# VGND VGND sky130_fd_pr__nfet_01v8 ad=2.34 pd=9 as=2.34 ps=9 w=3.9 l=0.2
X505 newdene_0/sw_0/a_n540_120# newdene_0/li_5730_n12230# VDPWR VDPWR sky130_fd_pr__pfet_01v8 ad=3 pd=11.2 as=3 ps=11.2 w=5 l=0.2
X506 newdene_0/sw_0/a_n180_n2470# newdene_0/sw_0/a_n540_n2470# VGND VGND sky130_fd_pr__nfet_01v8 ad=1.17 pd=4.5 as=2.34 ps=9 w=3.9 l=0.2
X507 newdene_0/sw_0/a_n540_n5000# newdene_0/li_5730_n12230# VGND VGND sky130_fd_pr__nfet_01v8 ad=2.34 pd=9 as=2.34 ps=9 w=3.9 l=0.2
X508 newdene_0/sw_0/a_n540_n2470# newdene_0/li_5730_n12230# VDPWR VDPWR sky130_fd_pr__pfet_01v8 ad=3 pd=11.2 as=3 ps=11.2 w=5 l=0.2
X509 newdene_0/li_7680_n13980# ui_in[0] newdene_0/sw_0/a_n180_n3690# VGND sky130_fd_pr__nfet_01v8 ad=2.34 pd=9 as=1.17 ps=4.5 w=3.9 l=0.2
X510 newdene_0/sw_0/a_n540_n2470# newdene_0/li_5730_n12230# VGND VGND sky130_fd_pr__nfet_01v8 ad=2.34 pd=9 as=2.34 ps=9 w=3.9 l=0.2
X511 newdene_0/li_7680_n13980# newdene_0/sw_0/a_n540_n5000# VDPWR VDPWR sky130_fd_pr__pfet_01v8 ad=1.5 pd=5.6 as=3 ps=11.2 w=5 l=0.2
X512 newdene_0/li_7710_n8950# newdene_0/sw_0/a_n540_120# VDPWR VDPWR sky130_fd_pr__pfet_01v8 ad=1.5 pd=5.6 as=3 ps=11.2 w=5 l=0.2
X513 VDPWR ui_in[1] newdene_0/li_7690_n11680# VDPWR sky130_fd_pr__pfet_01v8 ad=3 pd=11.2 as=1.5 ps=5.6 w=5 l=0.2
X514 newdene_0/sw_0/a_n180_1450# newdene_0/sw_0/a_n540_120# VGND VGND sky130_fd_pr__nfet_01v8 ad=1.17 pd=4.5 as=2.34 ps=9 w=3.9 l=0.2
X515 newdene_0/li_7710_n8950# ui_in[2] newdene_0/sw_0/a_n180_1450# VGND sky130_fd_pr__nfet_01v8 ad=2.34 pd=9 as=1.17 ps=4.5 w=3.9 l=0.2
X516 newdene_0/li_7690_n11680# ui_in[1] newdene_0/sw_0/a_n180_n2470# VGND sky130_fd_pr__nfet_01v8 ad=2.34 pd=9 as=1.17 ps=4.5 w=3.9 l=0.2
X517 newdene_0/sw_0/a_n540_n5000# newdene_0/li_5730_n12230# VDPWR VDPWR sky130_fd_pr__pfet_01v8 ad=3 pd=11.2 as=3 ps=11.2 w=5 l=0.2
X518 newdene_0/sw_0/a_n180_n3690# newdene_0/sw_0/a_n540_n5000# VGND VGND sky130_fd_pr__nfet_01v8 ad=1.17 pd=4.5 as=2.34 ps=9 w=3.9 l=0.2
X519 newdene_0/a_1120_n13160# newdene_0/AND_0/b clk VGND sky130_fd_pr__nfet_01v8 ad=6 pd=21.2 as=6 ps=21.2 w=10 l=0.2
X520 newdene_0/a_1120_n13160# newdene_0/a_1030_n8160# clk VDPWR sky130_fd_pr__pfet_01v8 ad=7.2 pd=25.2 as=7.2 ps=25.2 w=12 l=0.2
X521 ua[0] newdene_0/a_8120_n13290# VGND VGND sky130_fd_pr__nfet_01v8 ad=2.4 pd=9.2 as=2.4 ps=9.2 w=4 l=0.2
X522 VDPWR rst_n newdene_0/a_8120_n13290# VDPWR sky130_fd_pr__pfet_01v8 ad=3 pd=11.2 as=3 ps=11.2 w=5 l=0.2
X523 VGND rst_n newdene_0/a_8120_n13290# VGND sky130_fd_pr__nfet_01v8 ad=1.5 pd=6.2 as=1.5 ps=6.2 w=2.5 l=0.2
X524 VGND newdene_0/AND_0/b newdene_0/a_1030_n8160# VGND sky130_fd_pr__nfet_01v8 ad=1.5 pd=6.2 as=1.5 ps=6.2 w=2.5 l=0.2
X525 VDPWR newdene_0/AND_0/b newdene_0/a_1030_n8160# VDPWR sky130_fd_pr__pfet_01v8 ad=3 pd=11.2 as=3 ps=11.2 w=5 l=0.2
C0 ui_in[4] ui_in[3] 11.43279f
C1 ui_in[2] ui_in[3] 5.30602f
C2 ui_in[0] rst_n 4.36049f
C3 VDPWR newdene_0/AND_0/out 6.39908f
C4 VDPWR uo_out[4] 2.44383f
C5 uio_in[2] uio_in[3] 7.42694f
C6 newdene_0/li_5730_n12230# VDPWR 2.25453f
C7 uo_out[6] VDPWR 2.46382f
C8 uo_out[5] uo_out[4] 2.24517f
C9 uo_out[3] uo_out[2] 2.3075f
C10 VDPWR ui_in[5] 2.27024f
C11 VDPWR ui_in[6] 2.33553f
C12 uo_out[5] VDPWR 2.44441f
C13 VDPWR uo_out[7] 2.91577f
C14 uo_out[3] uo_out[4] 2.31839f
C15 uo_out[6] uo_out[5] 2.25251f
C16 ui_in[6] ui_in[5] 8.62107f
C17 uo_out[6] uo_out[7] 2.7691f
C18 uio_in[1] uio_in[0] 7.36309f
C19 uo_out[1] VDPWR 2.39369f
C20 ui_in[1] VDPWR 2.15213f
C21 uo_out[3] VDPWR 2.49867f
C22 uio_in[2] uio_in[1] 7.91976f
C23 ui_in[4] VDPWR 2.21633f
C24 ui_in[2] VDPWR 2.06067f
C25 uo_out[1] uo_out[0] 2.06626f
C26 ui_in[4] ui_in[5] 10.15134f
C27 VDPWR rst_n 7.67176f
C28 VDPWR newdene_0/AND_0/b 2.67185f
C29 rst_n clk 4.24531f
C30 ui_in[0] ui_in[1] 6.32215f
C31 VDPWR ua[0] 3.03519f
C32 ui_in[2] ui_in[1] 5.94042f
C33 uio_in[4] uio_in[3] 4.86574f
C34 uo_out[2] VDPWR 2.44561f
C35 newdene_0/a_8120_n13290# VGND 3.5568f **FLOATING
C36 VDPWR VGND 0.29314p
C37 ui_in[0] VGND 11.17162f
C38 newdene_0/li_5730_n12230# VGND 4.48358f **FLOATING
C39 ui_in[1] VGND 7.83316f
C40 ui_in[2] VGND 6.99651f
C41 rst_n VGND 33.36046f
C42 newdene_0/counnew_0/a_n6192_13338# VGND 2.06956f **FLOATING
C43 newdene_0/counnew_0/a_n6012_15878# VGND 2.21609f **FLOATING
C44 uo_out[0] VGND 9.28055f
C45 uo_out[1] VGND 7.38607f
C46 newdene_0/counnew_0/a_5648_18858# VGND 2.48296f **FLOATING
C47 uo_out[2] VGND 6.53136f
C48 newdene_0/counnew_0/a_3508_18858# VGND 2.48296f **FLOATING
C49 uo_out[3] VGND 5.83064f
C50 newdene_0/counnew_0/a_1368_18858# VGND 2.48296f **FLOATING
C51 uo_out[4] VGND 7.09068f
C52 newdene_0/counnew_0/a_n772_18858# VGND 2.48296f **FLOATING
C53 uo_out[5] VGND 7.98033f
C54 newdene_0/counnew_0/a_n2912_18858# VGND 2.4857f **FLOATING
C55 uo_out[6] VGND 8.29031f
C56 uo_out[7] VGND 10.94763f
C57 ui_in[3] VGND 6.3632f
C58 ui_in[4] VGND 5.23968f
C59 ui_in[5] VGND 2.32981f
C60 ui_in[6] VGND 3.55228f
C61 newdene_0/m2_1930_n14060# VGND 4.05456f **FLOATING
C62 newdene_0/AND_0/b VGND 14.0924f
C63 newdene_0/a_1120_n13160# VGND 2.7846f **FLOATING
C64 ua[1] VGND 6.90708f
C65 newdene_0/compnew_0/a_n122_5000# VGND 2.66712f **FLOATING
C66 newdene_0/m2_4740_n7410# VGND 7.77415f **FLOATING
C67 ua[0] VGND 11.26995f
C68 newdene_0/AND_0/out VGND 17.68958f
C69 clk VGND 14.10022f
C70 newdene_0/a_1030_n8160# VGND 3.11629f **FLOATING
C71 uio_in[0] VGND 10.23705f
C72 uio_in[1] VGND 7.51286f
C73 uio_in[2] VGND 13.38441f
C74 uio_in[3] VGND 15.90564f
C75 uio_in[4] VGND 24.3851f
