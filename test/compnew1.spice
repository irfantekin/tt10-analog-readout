* SPICE3 file created from compnew.ext - technology: sky130A

.lib /usr/local/share/pdk/sky130A/libs.tech/ngspice/sky130.lib.spice tt

Vpower VDPWR VGND 1.8
Vgnd VGND 0 DC 0

V2 resetp VGND pulse(0 1.8 80n 1n 1n 10ms 10ms)
V1 resetp1 VGND pulse(0 1.8 80n 1n 1n 10ms 10ms)
V3 ui_in[2] VGND 0
V4 clk VGND pulse(0 1.8 100n 1n 1n 25n 50n)
V5 ui_in[0] VGND 0

X0 VGND a_n2560_3460# a_n2400_2680# VGND sky130_fd_pr__nfet_01v8 ad=0.6 pd=3.2 as=0.6 ps=3.2 w=1 l=0.2
X1 a_n80_2480# a_160_4380# VGND VGND sky130_fd_pr__nfet_01v8 ad=1.2 pd=5.2 as=1.2 ps=5.2 w=2 l=0.2
X2 VDPWR ugate upgatein VDPWR sky130_fd_pr__pfet_01v8 ad=1.8 pd=7.2 as=1.8 ps=7.2 w=3 l=0.2
X3 VDPWR a_n200_2520# a_900_2120# VDPWR sky130_fd_pr__pfet_01v8 ad=2.6 pd=9.3 as=2.6 ps=9.3 w=4 l=0.4
X4 a_2320_2240# resetp1 VDPWR VDPWR sky130_fd_pr__pfet_01v8 ad=0.6 pd=3.2 as=0.6 ps=3.2 w=1 l=0.2
X5 VGND a_160_4380# a_160_4380# VGND sky130_fd_pr__nfet_01v8 ad=1.2 pd=5.2 as=1.2 ps=5.2 w=2 l=0.2
X6 lowgateout ugate ugate VGND sky130_fd_pr__nfet_01v8 ad=0.6 pd=3.2 as=0.6 ps=3.2 w=1 l=1
X7 lowgateout lowgate VDPWR VGND sky130_fd_pr__nfet_01v8 ad=0.6 pd=3.2 as=0.6 ps=3.2 w=1 l=0.2
X8 a_1110_3040# a_n200_2520# a_900_4180# VGND sky130_fd_pr__nfet_01v8 ad=1.3 pd=5.3 as=1.3 ps=5.3 w=2 l=0.4
X9 lowgateout lowgateout ugate VDPWR sky130_fd_pr__pfet_01v8 ad=2.4 pd=9.2 as=2.4 ps=9.2 w=4 l=0.15
X10 VGND a_n200_2520# a_900_4180# VGND sky130_fd_pr__nfet_01v8 ad=1.3 pd=5.3 as=1.3 ps=5.3 w=2 l=0.4
X11 lowgate lowgate VGND VGND sky130_fd_pr__nfet_01v8 ad=1.2 pd=5.2 as=1.2 ps=5.2 w=2 l=3.5
X12 a_n2560_3460# resetp VDPWR VDPWR sky130_fd_pr__pfet_01v8 ad=0.6 pd=3.2 as=0.6 ps=3.2 w=1 l=0.2
X13 VGND lowgateout a_n200_2520# VGND sky130_fd_pr__nfet_01v8 ad=3 pd=11.2 as=3 ps=11.2 w=5 l=0.15
X14 a_n420_2080# a_n80_2480# a_n200_2520# VDPWR sky130_fd_pr__pfet_01v8 ad=2.4 pd=9.2 as=2.4 ps=9.2 w=4 l=0.15
X15 VDPWR a_n420_2080# a_n540_2160# VDPWR sky130_fd_pr__pfet_01v8 ad=4.8 pd=17.2 as=2.4 ps=8.6 w=8 l=0.15
X16 a_n420_2080# a_n420_2080# VDPWR VDPWR sky130_fd_pr__pfet_01v8 ad=0.6 pd=3.2 as=0.6 ps=3.2 w=1 l=0.15
X17 a_2280_2580# resetp1 VDPWR VDPWR sky130_fd_pr__pfet_01v8 ad=0.6 pd=3.2 as=0.6 ps=3.2 w=1 l=0.2
X18 a_2280_2580# resetp1 VGND VGND sky130_fd_pr__nfet_01v8 ad=0.6 pd=3.2 as=0.6 ps=3.2 w=1 l=0.2
X19 lowgateout lowgateout VGND VGND sky130_fd_pr__nfet_01v8 ad=0.6 pd=3.2 as=0.6 ps=3.2 w=1 l=1
X20 a_n80_2480# a_580_1620# a_n540_2160# VDPWR sky130_fd_pr__pfet_01v8 ad=6 pd=21.2 as=6 ps=21.2 w=10 l=0.15
X21 lowgate a_2320_2240# VGND sky130_fd_pr__res_high_po w=1 l=5.16
X22 VDPWR ugate ugate VDPWR sky130_fd_pr__pfet_01v8 ad=2.4 pd=9.2 as=2.4 ps=9.2 w=4 l=0.15
X23 a_n540_2160# a_150_1620# a_160_4380# VDPWR sky130_fd_pr__pfet_01v8 ad=6 pd=21.2 as=6 ps=21.2 w=10 l=0.15
X24 a_1110_3040# a_n200_2520# a_900_2120# VDPWR sky130_fd_pr__pfet_01v8 ad=2.6 pd=9.3 as=2.6 ps=9.3 w=4 l=0.4
X25 a_n540_2160# ugate VDPWR VDPWR sky130_fd_pr__pfet_01v8 ad=2.4 pd=8.6 as=4.8 ps=17.2 w=8 l=0.15
X26 ugate upgatein a_n2400_2680# VDPWR sky130_fd_pr__pfet_01v8 ad=1.2 pd=5.2 as=1.2 ps=5.2 w=2 l=0.2
X27 a_n2400_2680# upgatein VGND sky130_fd_pr__res_high_po w=1 l=5.16
X28 VDPWR ugate ugate VDPWR sky130_fd_pr__pfet_01v8 ad=0.6 pd=3.2 as=0.6 ps=3.2 w=1 l=2
X29 lowgateout lowgateout VGND VGND sky130_fd_pr__nfet_01v8 ad=3 pd=11.2 as=3 ps=11.2 w=5 l=0.15
X30 VGND resetp a_n2400_2680# VDPWR sky130_fd_pr__pfet_01v8 ad=0.6 pd=3.2 as=0.6 ps=3.2 w=1 l=0.2
X31 a_n2560_3460# resetp VGND VGND sky130_fd_pr__nfet_01v8 ad=0.6 pd=3.2 as=0.6 ps=3.2 w=1 l=0.2
X32 a_2320_2240# a_2280_2580# VDPWR VGND sky130_fd_pr__nfet_01v8 ad=0.6 pd=3.2 as=0.6 ps=3.2 w=1 l=0.2
C0 ugate VDPWR 3.55083f
C1 lowgate VGND 2.83424f
C2 lowgateout VGND 3.78077f
C3 VDPWR VGND 35.724f

.tran 1n 500n
